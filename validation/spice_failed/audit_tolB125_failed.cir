P1 generic nonlinear T-type circuit: audit_tolB125
* Generic diode-plus-gated-switch surrogate; no device calibration.
Vpos pos 0 150
Vneg neg 0 -150
.model gateSW SW(Ron=0.001 Roff=1e9 Vt=0.5 Vh=0)
.model transistorD D(Is=1e-15 N=1 Rs=0.015 Cjo=20p Tt=0)
.model antiparallelD D(Is=1e-13 N=1 Rs=0.015 Cjo=20p Tt=0)
.temp 75
.options reltol=1e-5 abstol=1e-6 vntol=1e-6 method=gear maxord=2 rshunt=1e8 itl4=200
Rneutral neutral 0 1e9
.save i(La) i(Lb) i(Lc)
Vga1 ga1 0 PWL(
+ 0 0 0.00025095 0 0.00025105 1 0.00044995 1 0.00045005 0 0.00100095 0
+ 0.00100105 1 0.00104995 1 0.00105005 0 0.00145095 0 0.00145105 1 0.00149995 1
+ 0.00150005 0 0.00205095 0 0.00205105 1 0.00209995 1 0.00210005 0 0.00215095 0
+ 0.00215105 1 0.00279995 1 0.00280005 0 0.00335095 0 0.00335105 1 0.00344995 1
+ 0.00345005 0 0.00350095 0 0.00350105 1 0.00379995 1 0.00380005 0 0.00385095 0
+ 0.00385105 1 0.00394995 1 0.00395005 0 0.00400095 0 0.00400105 1 0.00419995 1
+ 0.00420005 0 0.00425095 0 0.00425105 1 0.00434995 1 0.00435005 0 0.00440095 0
+ 0.00440105 1 0.00479995 1 0.00480005 0 0.00485095 0 0.00485105 1 0.00494995 1
+ 0.00495005 0 0.00500095 0 0.00500105 1 0.00514995 1 0.00515005 0 0.00520095 0
+ 0.00520105 1 0.00539995 1 0.00540005 0 0.00545095 0 0.00545105 1 0.00564995 1
+ 0.00565005 0 0.00570095 0 0.00570105 1 0.00609995 1 0.00610005 0 0.00615095 0
+ 0.00615105 1 0.00639995 1 0.00640005 0 0.00645095 0 0.00645105 1 0.00664995 1
+ 0.00665005 0 0.00755095 0 0.00755105 1 0.00779995 1 0.00780005 0 0.00800095 0
+ 0.00800105 1 0.00824995 1 0.00825005 0 0.00835095 0 0.00835105 1 0.00839995 1
+ 0.00840005 0 0.00940095 0 0.00940105 1 0.00949995 1 0.00950005 0 0.00955095 0
+ 0.00955105 1 0.00964995 1 0.00965005 0 0.00975095 0 0.00975105 1 0.00979995 1
+ 0.00980005 0 0.01000095 0 0.01000105 1 0.01034995 1 0.01035005 0 0.01185095 0
+ 0.01185105 1 0.01189995 1 0.01190005 0 0.01255095 0 0.01255105 1 0.01274995 1
+ 0.01275005 0 0.01310095 0 0.01310105 1 0.01334995 1 0.01335005 0 0.01340095 0
+ 0.01340105 1 0.01374995 1 0.01375005 0 0.01380095 0 0.01380105 1 0.01384995 1
+ 0.01385005 0 0.01420095 0 0.01420105 1 0.01444995 1 0.01445005 0 0.01450095 0
+ 0.01450105 1 0.01454995 1 0.01455005 0 0.01465095 0 0.01465105 1 0.01469995 1
+ 0.01470005 0 0.01520095 0 0.01520105 1 0.01529995 1 0.01530005 0 0.01535095 0
+ 0.01535105 1 0.01609995 1 0.01610005 0 0.01695095 0 0.01695105 1 0.01704995 1
+ 0.01705005 0 0.01710095 0 0.01710105 1 0.01714995 1 0.01715005 0 0.01720095 0
+ 0.01720105 1 0.01744995 1 0.01745005 0 0.01750095 0 0.01750105 1 0.01759995 1
+ 0.01760005 0 0.01765095 0 0.01765105 1 0.01769995 1 0.01770005 0 0.01775095 0
+ 0.01775105 1 0.01779995 1 0.01780005 0 0.01790095 0 0.01790105 1 0.01799995 1
+ 0.01800005 0 0.01805095 0 0.01805105 1 0.01814995 1 0.01815005 0 0.01820095 0
+ 0.01820105 1 0.01824995 1 0.01825005 0 0.01830095 0 0.01830105 1 0.01839995 1
+ 0.01840005 0 0.01845095 0 0.01845105 1 0.01864995 1 0.01865005 0 0.01870095 0
+ 0.01870105 1 0.01884995 1 0.01885005 0 0.01890095 0 0.01890105 1 0.01894995 1
+ 0.01895005 0 0.01900095 0 0.01900105 1 0.01909995 1 0.01910005 0 0.01915095 0
+ 0.01915105 1 0.01919995 1 0.01920005 0 0.01925095 0 0.01925105 1 0.01929995 1
+ 0.01930005 0 0.01940095 0 0.01940105 1 0.01954995 1 0.01955005 0 0.01995095 0
+ 0.01995105 1 0.02004995 1 0.02005005 0 0.02010095 0 0.02010105 1 0.02019995 1
+ 0.02020005 0 0.02025095 0 0.02025105 1 0.02029995 1 0.02030005 0 0.02035095 0
+ 0.02035105 1 0.02049995 1 0.02050005 0 0.02065095 0 0.02065105 1 0.02069995 1
+ 0.02070005 0 0.02075095 0 0.02075105 1 0.02089995 1 0.02090005 0 0.02180095 0
+ 0.02180105 1 0.02189995 1 0.02190005 0 0.02195095 0 0.02195105 1 0.02204995 1
+ 0.02205005 0 0.02210095 0 0.02210105 1 0.02224995 1 0.02225005 0 0.02765095 0
+ 0.02765105 1 0.02774995 1 0.02775005 0 0.02780095 0 0.02780105 1 0.02789995 1
+ 0.02790005 0 0.02795095 0 0.02795105 1 0.02799995 1 0.02800005 0 0.02825095 0
+ 0.02825105 1 0.02829995 1 0.02830005 0 0.02835095 0 0.02835105 1 0.02849995 1
+ 0.02850005 0 0.02855095 0 0.02855105 1 0.02864995 1 0.02865005 0 0.02870095 0
+ 0.02870105 1 0.02879995 1 0.02880005 0 0.02935095 0 0.02935105 1 0.02939995 1
+ 0.02940005 0 0.02950095 0 0.02950105 1 0.02954995 1 0.02955005 0 0.02960095 0
+ 0.02960105 1 0.02969995 1 0.02970005 0 0.02980095 0 0.02980105 1 0.02984995 1
+ 0.02985005 0 0.02995095 0 0.02995105 1 0.02999995 1 0.03000005 0 0.03010095 0
+ 0.03010105 1 0.03014995 1 0.03015005 0 0.03020095 0 0.03020105 1 0.03024995 1
+ 0.03025005 0 0.03050095 0 0.03050105 1 0.03059995 1 0.03060005 0 0.03065095 0
+ 0.03065105 1 0.03074995 1 0.03075005 0 0.03110095 0 0.03110105 1 0.03114995 1
+ 0.03115005 0 0.03125095 0 0.03125105 1 0.03129995 1 0.03130005 0 0.03135095 0
+ 0.03135105 1 0.03139995 1 0.03140005 0 0.03150095 0 0.03150105 1 0.03154995 1
+ 0.03155005 0 0.03165095 0 0.03165105 1 0.03169995 1 0.03170005 0 0.03175095 0
+ 0.03175105 1 0.03179995 1 0.03180005 0 0.03190095 0 0.03190105 1 0.03199995 1
+ 0.03200005 0 0.03210095 0 0.03210105 1 0.03214995 1 0.03215005 0 0.03220095 0
+ 0.03220105 1 0.03224995 1 0.03225005 0 0.03235095 0 0.03235105 1 0.03239995 1
+ 0.03240005 0 0.03245095 0 0.03245105 1 0.03254995 1 0.03255005 0 0.03260095 0
+ 0.03260105 1 0.03269995 1 0.03270005 0 0.03275095 0 0.03275105 1 0.03279995 1
+ 0.03280005 0 0.03290095 0 0.03290105 1 0.03299995 1 0.03300005 0 0.03305095 0
+ 0.03305105 1 0.03309995 1 0.03310005 0 0.03320095 0 0.03320105 1 0.03324995 1
+ 0.03325005 0 0.03330095 0 0.03330105 1 0.03339995 1 0.03340005 0 0.03350095 0
+ 0.03350105 1 0.03354995 1 0.03355005 0 0.03360095 0 0.03360105 1 0.03369995 1
+ 0.03370005 0 0.03390095 0 0.03390105 1 0.03399995 1 0.03400005 0 0.03405095 0
+ 0.03405105 1 0.03409995 1 0.03410005 0 0.03465095 0 0.03465105 1 0.03469995 1
+ 0.03470005 0 0.03920095 0 0.03920105 1 0.03939995 1 0.03940005 0 0.03950095 0
+ 0.03950105 1 0.03964995 1 0.03965005 0 0.04050095 0 0.04050105 1 0.04054995 1
+ 0.04055005 0 0.04095095 0 0.04095105 1 0.04099995 1 0.04100005 0 0.04140095 0
+ 0.04140105 1 0.04144995 1 0.04145005 0 0.04150095 0 0.04150105 1 0.04189995 1
+ 0.04190005 0 0.04235095 0 0.04235105 1 0.04239995 1 0.04240005 0 0.04245095 0
+ 0.04245105 1 0.04274995 1 0.04275005 0 0.04280095 0 0.04280105 1 0.04309995 1
+ 0.04310005 0 0.04315095 0 0.04315105 1 0.04324995 1 0.04325005 0 0.04330095 0
+ 0.04330105 1 0.04359995 1 0.04360005 0 0.04365095 0 0.04365105 1 0.04384995 1
+ 0.04385005 0 0.04390095 0 0.04390105 1 0.04419995 1 0.04420005 0 0.04425095 0
+ 0.04425105 1 0.04444995 1 0.04445005 0 0.04450095 0 0.04450105 1 0.04479995 1
+ 0.04480005 0 0.04485095 0 0.04485105 1 0.04534995 1 0.04535005 0 0.04540095 0
+ 0.04540105 1 0.04554995 1 0.04555005 0 0.04560095 0 0.04560105 1 0.04609995 1
+ 0.04610005 0 0.04615095 0 0.04615105 1 0.04639995 1 0.04640005 0 0.04645095 0
+ 0.04645105 1 0.04669995 1 0.04670005 0 0.04680095 0 0.04680105 1 0.04704995 1
+ 0.04705005 0 0.04720095 0 0.04720105 1 0.04744995 1 0.04745005 0 0.04885095 0
+ 0.04885105 1 0.04889995 1 0.04890005 0 0.0512 0
+ )
Vga2 ga2 0 PWL(
+ 0 1 5e-08 0 0.00015095 0 0.00015105 1 0.00064995 1 0.00065005 0
+ 0.00070095 0 0.00070105 1 0.00074995 1 0.00075005 0 0.00090095 0 0.00090105 1
+ 0.00109995 1 0.00110005 0 0.00120095 0 0.00120105 1 0.00124995 1 0.00125005 0
+ 0.00135095 0 0.00135105 1 0.00154995 1 0.00155005 0 0.00165095 0 0.00165105 1
+ 0.00169995 1 0.00170005 0 0.00185095 0 0.00185105 1 0.00189995 1 0.00190005 0
+ 0.00195095 0 0.00195105 1 0.00284995 1 0.00285005 0 0.00290095 0 0.00290105 1
+ 0.00299995 1 0.00300005 0 0.00310095 0 0.00310105 1 0.00314995 1 0.00315005 0
+ 0.00325095 0 0.00325105 1 0.00669995 1 0.00670005 0 0.00675095 0 0.00675105 1
+ 0.00679995 1 0.00680005 0 0.00690095 0 0.00690105 1 0.00699995 1 0.00700005 0
+ 0.00705095 0 0.00705105 1 0.00709995 1 0.00710005 0 0.00720095 0 0.00720105 1
+ 0.00724995 1 0.00725005 0 0.00735095 0 0.00735105 1 0.00844995 1 0.00845005 0
+ 0.00850095 0 0.00850105 1 0.00854995 1 0.00855005 0 0.00865095 0 0.00865105 1
+ 0.00869995 1 0.00870005 0 0.00885095 0 0.00885105 1 0.00889995 1 0.00890005 0
+ 0.00900095 0 0.00900105 1 0.00904995 1 0.00905005 0 0.00915095 0 0.00915105 1
+ 0.00924995 1 0.00925005 0 0.00930095 0 0.00930105 1 0.00984995 1 0.00985005 0
+ 0.00990095 0 0.00990105 1 0.01039995 1 0.01040005 0 0.01045095 0 0.01045105 1
+ 0.01054995 1 0.01055005 0 0.01060095 0 0.01060105 1 0.01069995 1 0.01070005 0
+ 0.01075095 0 0.01075105 1 0.01084995 1 0.01085005 0 0.01090095 0 0.01090105 1
+ 0.01094995 1 0.01095005 0 0.01100095 0 0.01100105 1 0.01109995 1 0.01110005 0
+ 0.01120095 0 0.01120105 1 0.01124995 1 0.01125005 0 0.01135095 0 0.01135105 1
+ 0.01149995 1 0.01150005 0 0.01160095 0 0.01160105 1 0.01169995 1 0.01170005 0
+ 0.01175095 0 0.01175105 1 0.01194995 1 0.01195005 0 0.01200095 0 0.01200105 1
+ 0.01209995 1 0.01210005 0 0.01215095 0 0.01215105 1 0.01219995 1 0.01220005 0
+ 0.01225095 0 0.01225105 1 0.01234995 1 0.01235005 0 0.01245095 0 0.01245105 1
+ 0.01279995 1 0.01280005 0 0.01285095 0 0.01285105 1 0.01289995 1 0.01290005 0
+ 0.01300095 0 0.01300105 1 0.01389995 1 0.01390005 0 0.01400095 0 0.01400105 1
+ 0.01474995 1 0.01475005 0 0.01485095 0 0.01485105 1 0.01489995 1 0.01490005 0
+ 0.01495095 0 0.01495105 1 0.01614995 1 0.01615005 0 0.01620095 0 0.01620105 1
+ 0.01629995 1 0.01630005 0 0.01635095 0 0.01635105 1 0.01644995 1 0.01645005 0
+ 0.01655095 0 0.01655105 1 0.01659995 1 0.01660005 0 0.01670095 0 0.01670105 1
+ 0.01674995 1 0.01675005 0 0.01685095 0 0.01685105 1 0.01959995 1 0.01960005 0
+ 0.01985095 0 0.01985105 1 0.02094995 1 0.02095005 0 0.02145095 0 0.02145105 1
+ 0.02164995 1 0.02165005 0 0.02175095 0 0.02175105 1 0.02259995 1 0.02260005 0
+ 0.02265095 0 0.02265105 1 0.02274995 1 0.02275005 0 0.02315095 0 0.02315105 1
+ 0.02319995 1 0.02320005 0 0.02330095 0 0.02330105 1 0.02334995 1 0.02335005 0
+ 0.02345095 0 0.02345105 1 0.02349995 1 0.02350005 0 0.02385095 0 0.02385105 1
+ 0.02389995 1 0.02390005 0 0.02400095 0 0.02400105 1 0.02404995 1 0.02405005 0
+ 0.02415095 0 0.02415105 1 0.02419995 1 0.02420005 0 0.02440095 0 0.02440105 1
+ 0.02444995 1 0.02445005 0 0.02500095 0 0.02500105 1 0.02504995 1 0.02505005 0
+ 0.02525095 0 0.02525105 1 0.02529995 1 0.02530005 0 0.02540095 0 0.02540105 1
+ 0.02544995 1 0.02545005 0 0.02595095 0 0.02595105 1 0.02599995 1 0.02600005 0
+ 0.02620095 0 0.02620105 1 0.02624995 1 0.02625005 0 0.02650095 0 0.02650105 1
+ 0.02654995 1 0.02655005 0 0.02690095 0 0.02690105 1 0.02694995 1 0.02695005 0
+ 0.02720095 0 0.02720105 1 0.02724995 1 0.02725005 0 0.02750095 0 0.02750105 1
+ 0.02904995 1 0.02905005 0 0.02910095 0 0.02910105 1 0.03034995 1 0.03035005 0
+ 0.03045095 0 0.03045105 1 0.03084995 1 0.03085005 0 0.03105095 0 0.03105105 1
+ 0.03379995 1 0.03380005 0 0.03385095 0 0.03385105 1 0.03419995 1 0.03420005 0
+ 0.03460095 0 0.03460105 1 0.03479995 1 0.03480005 0 0.03555095 0 0.03555105 1
+ 0.03559995 1 0.03560005 0 0.03570095 0 0.03570105 1 0.03589995 1 0.03590005 0
+ 0.03600095 0 0.03600105 1 0.03604995 1 0.03605005 0 0.03615095 0 0.03615105 1
+ 0.03619995 1 0.03620005 0 0.03630095 0 0.03630105 1 0.03634995 1 0.03635005 0
+ 0.03665095 0 0.03665105 1 0.03669995 1 0.03670005 0 0.03675095 0 0.03675105 1
+ 0.03679995 1 0.03680005 0 0.03685095 0 0.03685105 1 0.03689995 1 0.03690005 0
+ 0.03705095 0 0.03705105 1 0.03709995 1 0.03710005 0 0.03720095 0 0.03720105 1
+ 0.03724995 1 0.03725005 0 0.03750095 0 0.03750105 1 0.03754995 1 0.03755005 0
+ 0.03760095 0 0.03760105 1 0.03764995 1 0.03765005 0 0.03780095 0 0.03780105 1
+ 0.03784995 1 0.03785005 0 0.03805095 0 0.03805105 1 0.03809995 1 0.03810005 0
+ 0.03840095 0 0.03840105 1 0.03844995 1 0.03845005 0 0.03850095 0 0.03850105 1
+ 0.03854995 1 0.03855005 0 0.03880095 0 0.03880105 1 0.03884995 1 0.03885005 0
+ 0.03895095 0 0.03895105 1 0.03899995 1 0.03900005 0 0.03915095 0 0.03915105 1
+ 0.03974995 1 0.03975005 0 0.03980095 0 0.03980105 1 0.03984995 1 0.03985005 0
+ 0.04000095 0 0.04000105 1 0.04014995 1 0.04015005 0 0.04025095 0 0.04025105 1
+ 0.04029995 1 0.04030005 0 0.04045095 0 0.04045105 1 0.04059995 1 0.04060005 0
+ 0.04070095 0 0.04070105 1 0.04074995 1 0.04075005 0 0.04085095 0 0.04085105 1
+ 0.04104995 1 0.04105005 0 0.04115095 0 0.04115105 1 0.04119995 1 0.04120005 0
+ 0.04130095 0 0.04130105 1 0.04204995 1 0.04205005 0 0.04210095 0 0.04210105 1
+ 0.04754995 1 0.04755005 0 0.04760095 0 0.04760105 1 0.04764995 1 0.04765005 0
+ 0.04775095 0 0.04775105 1 0.04779995 1 0.04780005 0 0.04790095 0 0.04790105 1
+ 0.04799995 1 0.04800005 0 0.04805095 0 0.04805105 1 0.04814995 1 0.04815005 0
+ 0.04820095 0 0.04820105 1 0.04824995 1 0.04825005 0 0.04840095 0 0.04840105 1
+ 0.04844995 1 0.04845005 0 0.04855095 0 0.04855105 1 0.04864995 1 0.04865005 0
+ 0.04870095 0 0.04870105 1 0.04894995 1 0.04895005 0 0.04900095 0 0.04900105 1
+ 0.04909995 1 0.04910005 0 0.04920095 0 0.04920105 1 0.04924995 1 0.04925005 0
+ 0.04935095 0 0.04935105 1 0.04944995 1 0.04945005 0 0.04955095 0 0.04955105 1
+ 0.04959995 1 0.04960005 0 0.04970095 0 0.04970105 1 0.04979995 1 0.04980005 0
+ 0.04990095 0 0.04990105 1 0.04994995 1 0.04995005 0 0.05005095 0 0.05005105 1
+ 0.05014995 1 0.05015005 0 0.05020095 0 0.05020105 1 0.05029995 1 0.05030005 0
+ 0.05035095 0 0.05035105 1 0.05039995 1 0.05040005 0 0.05050095 0 0.05050105 1
+ 0.05054995 1 0.05055005 0 0.05065095 0 0.05065105 1 0.05074995 1 0.05075005 0
+ 0.05085095 0 0.05085105 1 0.05094995 1 0.05095005 0 0.05100095 0 0.05100105 1
+ 0.05109995 1 0.05110005 0 0.05115095 0 0.05115105 1 0.0512 1
+ )
Vga3 ga3 0 PWL(
+ 0 1 0.00024995 1 0.00025005 0 0.00045095 0 0.00045105 1 0.00099995 1
+ 0.00100005 0 0.00105095 0 0.00105105 1 0.00144995 1 0.00145005 0 0.00150095 0
+ 0.00150105 1 0.00204995 1 0.00205005 0 0.00210095 0 0.00210105 1 0.00214995 1
+ 0.00215005 0 0.00280095 0 0.00280105 1 0.00334995 1 0.00335005 0 0.00345095 0
+ 0.00345105 1 0.00349995 1 0.00350005 0 0.00380095 0 0.00380105 1 0.00384995 1
+ 0.00385005 0 0.00395095 0 0.00395105 1 0.00399995 1 0.00400005 0 0.00420095 0
+ 0.00420105 1 0.00424995 1 0.00425005 0 0.00435095 0 0.00435105 1 0.00439995 1
+ 0.00440005 0 0.00480095 0 0.00480105 1 0.00484995 1 0.00485005 0 0.00495095 0
+ 0.00495105 1 0.00499995 1 0.00500005 0 0.00515095 0 0.00515105 1 0.00519995 1
+ 0.00520005 0 0.00540095 0 0.00540105 1 0.00544995 1 0.00545005 0 0.00565095 0
+ 0.00565105 1 0.00569995 1 0.00570005 0 0.00610095 0 0.00610105 1 0.00614995 1
+ 0.00615005 0 0.00640095 0 0.00640105 1 0.00644995 1 0.00645005 0 0.00665095 0
+ 0.00665105 1 0.00754995 1 0.00755005 0 0.00780095 0 0.00780105 1 0.00799995 1
+ 0.00800005 0 0.00825095 0 0.00825105 1 0.00834995 1 0.00835005 0 0.00840095 0
+ 0.00840105 1 0.00939995 1 0.00940005 0 0.00950095 0 0.00950105 1 0.00954995 1
+ 0.00955005 0 0.00965095 0 0.00965105 1 0.00974995 1 0.00975005 0 0.00980095 0
+ 0.00980105 1 0.00999995 1 0.01000005 0 0.01035095 0 0.01035105 1 0.01184995 1
+ 0.01185005 0 0.01190095 0 0.01190105 1 0.01254995 1 0.01255005 0 0.01275095 0
+ 0.01275105 1 0.01309995 1 0.01310005 0 0.01335095 0 0.01335105 1 0.01339995 1
+ 0.01340005 0 0.01375095 0 0.01375105 1 0.01379995 1 0.01380005 0 0.01385095 0
+ 0.01385105 1 0.01419995 1 0.01420005 0 0.01445095 0 0.01445105 1 0.01449995 1
+ 0.01450005 0 0.01455095 0 0.01455105 1 0.01464995 1 0.01465005 0 0.01470095 0
+ 0.01470105 1 0.01519995 1 0.01520005 0 0.01530095 0 0.01530105 1 0.01534995 1
+ 0.01535005 0 0.01610095 0 0.01610105 1 0.01694995 1 0.01695005 0 0.01705095 0
+ 0.01705105 1 0.01709995 1 0.01710005 0 0.01715095 0 0.01715105 1 0.01719995 1
+ 0.01720005 0 0.01745095 0 0.01745105 1 0.01749995 1 0.01750005 0 0.01760095 0
+ 0.01760105 1 0.01764995 1 0.01765005 0 0.01770095 0 0.01770105 1 0.01774995 1
+ 0.01775005 0 0.01780095 0 0.01780105 1 0.01789995 1 0.01790005 0 0.01800095 0
+ 0.01800105 1 0.01804995 1 0.01805005 0 0.01815095 0 0.01815105 1 0.01819995 1
+ 0.01820005 0 0.01825095 0 0.01825105 1 0.01829995 1 0.01830005 0 0.01840095 0
+ 0.01840105 1 0.01844995 1 0.01845005 0 0.01865095 0 0.01865105 1 0.01869995 1
+ 0.01870005 0 0.01885095 0 0.01885105 1 0.01889995 1 0.01890005 0 0.01895095 0
+ 0.01895105 1 0.01899995 1 0.01900005 0 0.01910095 0 0.01910105 1 0.01914995 1
+ 0.01915005 0 0.01920095 0 0.01920105 1 0.01924995 1 0.01925005 0 0.01930095 0
+ 0.01930105 1 0.01939995 1 0.01940005 0 0.01955095 0 0.01955105 1 0.01994995 1
+ 0.01995005 0 0.02005095 0 0.02005105 1 0.02009995 1 0.02010005 0 0.02020095 0
+ 0.02020105 1 0.02024995 1 0.02025005 0 0.02030095 0 0.02030105 1 0.02034995 1
+ 0.02035005 0 0.02050095 0 0.02050105 1 0.02064995 1 0.02065005 0 0.02070095 0
+ 0.02070105 1 0.02074995 1 0.02075005 0 0.02090095 0 0.02090105 1 0.02179995 1
+ 0.02180005 0 0.02190095 0 0.02190105 1 0.02194995 1 0.02195005 0 0.02205095 0
+ 0.02205105 1 0.02209995 1 0.02210005 0 0.02225095 0 0.02225105 1 0.02764995 1
+ 0.02765005 0 0.02775095 0 0.02775105 1 0.02779995 1 0.02780005 0 0.02790095 0
+ 0.02790105 1 0.02794995 1 0.02795005 0 0.02800095 0 0.02800105 1 0.02824995 1
+ 0.02825005 0 0.02830095 0 0.02830105 1 0.02834995 1 0.02835005 0 0.02850095 0
+ 0.02850105 1 0.02854995 1 0.02855005 0 0.02865095 0 0.02865105 1 0.02869995 1
+ 0.02870005 0 0.02880095 0 0.02880105 1 0.02934995 1 0.02935005 0 0.02940095 0
+ 0.02940105 1 0.02949995 1 0.02950005 0 0.02955095 0 0.02955105 1 0.02959995 1
+ 0.02960005 0 0.02970095 0 0.02970105 1 0.02979995 1 0.02980005 0 0.02985095 0
+ 0.02985105 1 0.02994995 1 0.02995005 0 0.03000095 0 0.03000105 1 0.03009995 1
+ 0.03010005 0 0.03015095 0 0.03015105 1 0.03019995 1 0.03020005 0 0.03025095 0
+ 0.03025105 1 0.03049995 1 0.03050005 0 0.03060095 0 0.03060105 1 0.03064995 1
+ 0.03065005 0 0.03075095 0 0.03075105 1 0.03109995 1 0.03110005 0 0.03115095 0
+ 0.03115105 1 0.03124995 1 0.03125005 0 0.03130095 0 0.03130105 1 0.03134995 1
+ 0.03135005 0 0.03140095 0 0.03140105 1 0.03149995 1 0.03150005 0 0.03155095 0
+ 0.03155105 1 0.03164995 1 0.03165005 0 0.03170095 0 0.03170105 1 0.03174995 1
+ 0.03175005 0 0.03180095 0 0.03180105 1 0.03189995 1 0.03190005 0 0.03200095 0
+ 0.03200105 1 0.03209995 1 0.03210005 0 0.03215095 0 0.03215105 1 0.03219995 1
+ 0.03220005 0 0.03225095 0 0.03225105 1 0.03234995 1 0.03235005 0 0.03240095 0
+ 0.03240105 1 0.03244995 1 0.03245005 0 0.03255095 0 0.03255105 1 0.03259995 1
+ 0.03260005 0 0.03270095 0 0.03270105 1 0.03274995 1 0.03275005 0 0.03280095 0
+ 0.03280105 1 0.03289995 1 0.03290005 0 0.03300095 0 0.03300105 1 0.03304995 1
+ 0.03305005 0 0.03310095 0 0.03310105 1 0.03319995 1 0.03320005 0 0.03325095 0
+ 0.03325105 1 0.03329995 1 0.03330005 0 0.03340095 0 0.03340105 1 0.03349995 1
+ 0.03350005 0 0.03355095 0 0.03355105 1 0.03359995 1 0.03360005 0 0.03370095 0
+ 0.03370105 1 0.03389995 1 0.03390005 0 0.03400095 0 0.03400105 1 0.03404995 1
+ 0.03405005 0 0.03410095 0 0.03410105 1 0.03464995 1 0.03465005 0 0.03470095 0
+ 0.03470105 1 0.03919995 1 0.03920005 0 0.03940095 0 0.03940105 1 0.03949995 1
+ 0.03950005 0 0.03965095 0 0.03965105 1 0.04049995 1 0.04050005 0 0.04055095 0
+ 0.04055105 1 0.04094995 1 0.04095005 0 0.04100095 0 0.04100105 1 0.04139995 1
+ 0.04140005 0 0.04145095 0 0.04145105 1 0.04149995 1 0.04150005 0 0.04190095 0
+ 0.04190105 1 0.04234995 1 0.04235005 0 0.04240095 0 0.04240105 1 0.04244995 1
+ 0.04245005 0 0.04275095 0 0.04275105 1 0.04279995 1 0.04280005 0 0.04310095 0
+ 0.04310105 1 0.04314995 1 0.04315005 0 0.04325095 0 0.04325105 1 0.04329995 1
+ 0.04330005 0 0.04360095 0 0.04360105 1 0.04364995 1 0.04365005 0 0.04385095 0
+ 0.04385105 1 0.04389995 1 0.04390005 0 0.04420095 0 0.04420105 1 0.04424995 1
+ 0.04425005 0 0.04445095 0 0.04445105 1 0.04449995 1 0.04450005 0 0.04480095 0
+ 0.04480105 1 0.04484995 1 0.04485005 0 0.04535095 0 0.04535105 1 0.04539995 1
+ 0.04540005 0 0.04555095 0 0.04555105 1 0.04559995 1 0.04560005 0 0.04610095 0
+ 0.04610105 1 0.04614995 1 0.04615005 0 0.04640095 0 0.04640105 1 0.04644995 1
+ 0.04645005 0 0.04670095 0 0.04670105 1 0.04679995 1 0.04680005 0 0.04705095 0
+ 0.04705105 1 0.04719995 1 0.04720005 0 0.04745095 0 0.04745105 1 0.04884995 1
+ 0.04885005 0 0.04890095 0 0.04890105 1 0.0512 1
+ )
Vga4 ga4 0 PWL(
+ 0 0 9.5e-07 0 1.05e-06 1 0.00014995 1 0.00015005 0 0.00065095 0
+ 0.00065105 1 0.00069995 1 0.00070005 0 0.00075095 0 0.00075105 1 0.00089995 1
+ 0.00090005 0 0.00110095 0 0.00110105 1 0.00119995 1 0.00120005 0 0.00125095 0
+ 0.00125105 1 0.00134995 1 0.00135005 0 0.00155095 0 0.00155105 1 0.00164995 1
+ 0.00165005 0 0.00170095 0 0.00170105 1 0.00184995 1 0.00185005 0 0.00190095 0
+ 0.00190105 1 0.00194995 1 0.00195005 0 0.00285095 0 0.00285105 1 0.00289995 1
+ 0.00290005 0 0.00300095 0 0.00300105 1 0.00309995 1 0.00310005 0 0.00315095 0
+ 0.00315105 1 0.00324995 1 0.00325005 0 0.00670095 0 0.00670105 1 0.00674995 1
+ 0.00675005 0 0.00680095 0 0.00680105 1 0.00689995 1 0.00690005 0 0.00700095 0
+ 0.00700105 1 0.00704995 1 0.00705005 0 0.00710095 0 0.00710105 1 0.00719995 1
+ 0.00720005 0 0.00725095 0 0.00725105 1 0.00734995 1 0.00735005 0 0.00845095 0
+ 0.00845105 1 0.00849995 1 0.00850005 0 0.00855095 0 0.00855105 1 0.00864995 1
+ 0.00865005 0 0.00870095 0 0.00870105 1 0.00884995 1 0.00885005 0 0.00890095 0
+ 0.00890105 1 0.00899995 1 0.00900005 0 0.00905095 0 0.00905105 1 0.00914995 1
+ 0.00915005 0 0.00925095 0 0.00925105 1 0.00929995 1 0.00930005 0 0.00985095 0
+ 0.00985105 1 0.00989995 1 0.00990005 0 0.01040095 0 0.01040105 1 0.01044995 1
+ 0.01045005 0 0.01055095 0 0.01055105 1 0.01059995 1 0.01060005 0 0.01070095 0
+ 0.01070105 1 0.01074995 1 0.01075005 0 0.01085095 0 0.01085105 1 0.01089995 1
+ 0.01090005 0 0.01095095 0 0.01095105 1 0.01099995 1 0.01100005 0 0.01110095 0
+ 0.01110105 1 0.01119995 1 0.01120005 0 0.01125095 0 0.01125105 1 0.01134995 1
+ 0.01135005 0 0.01150095 0 0.01150105 1 0.01159995 1 0.01160005 0 0.01170095 0
+ 0.01170105 1 0.01174995 1 0.01175005 0 0.01195095 0 0.01195105 1 0.01199995 1
+ 0.01200005 0 0.01210095 0 0.01210105 1 0.01214995 1 0.01215005 0 0.01220095 0
+ 0.01220105 1 0.01224995 1 0.01225005 0 0.01235095 0 0.01235105 1 0.01244995 1
+ 0.01245005 0 0.01280095 0 0.01280105 1 0.01284995 1 0.01285005 0 0.01290095 0
+ 0.01290105 1 0.01299995 1 0.01300005 0 0.01390095 0 0.01390105 1 0.01399995 1
+ 0.01400005 0 0.01475095 0 0.01475105 1 0.01484995 1 0.01485005 0 0.01490095 0
+ 0.01490105 1 0.01494995 1 0.01495005 0 0.01615095 0 0.01615105 1 0.01619995 1
+ 0.01620005 0 0.01630095 0 0.01630105 1 0.01634995 1 0.01635005 0 0.01645095 0
+ 0.01645105 1 0.01654995 1 0.01655005 0 0.01660095 0 0.01660105 1 0.01669995 1
+ 0.01670005 0 0.01675095 0 0.01675105 1 0.01684995 1 0.01685005 0 0.01960095 0
+ 0.01960105 1 0.01984995 1 0.01985005 0 0.02095095 0 0.02095105 1 0.02144995 1
+ 0.02145005 0 0.02165095 0 0.02165105 1 0.02174995 1 0.02175005 0 0.02260095 0
+ 0.02260105 1 0.02264995 1 0.02265005 0 0.02275095 0 0.02275105 1 0.02314995 1
+ 0.02315005 0 0.02320095 0 0.02320105 1 0.02329995 1 0.02330005 0 0.02335095 0
+ 0.02335105 1 0.02344995 1 0.02345005 0 0.02350095 0 0.02350105 1 0.02384995 1
+ 0.02385005 0 0.02390095 0 0.02390105 1 0.02399995 1 0.02400005 0 0.02405095 0
+ 0.02405105 1 0.02414995 1 0.02415005 0 0.02420095 0 0.02420105 1 0.02439995 1
+ 0.02440005 0 0.02445095 0 0.02445105 1 0.02499995 1 0.02500005 0 0.02505095 0
+ 0.02505105 1 0.02524995 1 0.02525005 0 0.02530095 0 0.02530105 1 0.02539995 1
+ 0.02540005 0 0.02545095 0 0.02545105 1 0.02594995 1 0.02595005 0 0.02600095 0
+ 0.02600105 1 0.02619995 1 0.02620005 0 0.02625095 0 0.02625105 1 0.02649995 1
+ 0.02650005 0 0.02655095 0 0.02655105 1 0.02689995 1 0.02690005 0 0.02695095 0
+ 0.02695105 1 0.02719995 1 0.02720005 0 0.02725095 0 0.02725105 1 0.02749995 1
+ 0.02750005 0 0.02905095 0 0.02905105 1 0.02909995 1 0.02910005 0 0.03035095 0
+ 0.03035105 1 0.03044995 1 0.03045005 0 0.03085095 0 0.03085105 1 0.03104995 1
+ 0.03105005 0 0.03380095 0 0.03380105 1 0.03384995 1 0.03385005 0 0.03420095 0
+ 0.03420105 1 0.03459995 1 0.03460005 0 0.03480095 0 0.03480105 1 0.03554995 1
+ 0.03555005 0 0.03560095 0 0.03560105 1 0.03569995 1 0.03570005 0 0.03590095 0
+ 0.03590105 1 0.03599995 1 0.03600005 0 0.03605095 0 0.03605105 1 0.03614995 1
+ 0.03615005 0 0.03620095 0 0.03620105 1 0.03629995 1 0.03630005 0 0.03635095 0
+ 0.03635105 1 0.03664995 1 0.03665005 0 0.03670095 0 0.03670105 1 0.03674995 1
+ 0.03675005 0 0.03680095 0 0.03680105 1 0.03684995 1 0.03685005 0 0.03690095 0
+ 0.03690105 1 0.03704995 1 0.03705005 0 0.03710095 0 0.03710105 1 0.03719995 1
+ 0.03720005 0 0.03725095 0 0.03725105 1 0.03749995 1 0.03750005 0 0.03755095 0
+ 0.03755105 1 0.03759995 1 0.03760005 0 0.03765095 0 0.03765105 1 0.03779995 1
+ 0.03780005 0 0.03785095 0 0.03785105 1 0.03804995 1 0.03805005 0 0.03810095 0
+ 0.03810105 1 0.03839995 1 0.03840005 0 0.03845095 0 0.03845105 1 0.03849995 1
+ 0.03850005 0 0.03855095 0 0.03855105 1 0.03879995 1 0.03880005 0 0.03885095 0
+ 0.03885105 1 0.03894995 1 0.03895005 0 0.03900095 0 0.03900105 1 0.03914995 1
+ 0.03915005 0 0.03975095 0 0.03975105 1 0.03979995 1 0.03980005 0 0.03985095 0
+ 0.03985105 1 0.03999995 1 0.04000005 0 0.04015095 0 0.04015105 1 0.04024995 1
+ 0.04025005 0 0.04030095 0 0.04030105 1 0.04044995 1 0.04045005 0 0.04060095 0
+ 0.04060105 1 0.04069995 1 0.04070005 0 0.04075095 0 0.04075105 1 0.04084995 1
+ 0.04085005 0 0.04105095 0 0.04105105 1 0.04114995 1 0.04115005 0 0.04120095 0
+ 0.04120105 1 0.04129995 1 0.04130005 0 0.04205095 0 0.04205105 1 0.04209995 1
+ 0.04210005 0 0.04755095 0 0.04755105 1 0.04759995 1 0.04760005 0 0.04765095 0
+ 0.04765105 1 0.04774995 1 0.04775005 0 0.04780095 0 0.04780105 1 0.04789995 1
+ 0.04790005 0 0.04800095 0 0.04800105 1 0.04804995 1 0.04805005 0 0.04815095 0
+ 0.04815105 1 0.04819995 1 0.04820005 0 0.04825095 0 0.04825105 1 0.04839995 1
+ 0.04840005 0 0.04845095 0 0.04845105 1 0.04854995 1 0.04855005 0 0.04865095 0
+ 0.04865105 1 0.04869995 1 0.04870005 0 0.04895095 0 0.04895105 1 0.04899995 1
+ 0.04900005 0 0.04910095 0 0.04910105 1 0.04919995 1 0.04920005 0 0.04925095 0
+ 0.04925105 1 0.04934995 1 0.04935005 0 0.04945095 0 0.04945105 1 0.04954995 1
+ 0.04955005 0 0.04960095 0 0.04960105 1 0.04969995 1 0.04970005 0 0.04980095 0
+ 0.04980105 1 0.04989995 1 0.04990005 0 0.04995095 0 0.04995105 1 0.05004995 1
+ 0.05005005 0 0.05015095 0 0.05015105 1 0.05019995 1 0.05020005 0 0.05030095 0
+ 0.05030105 1 0.05034995 1 0.05035005 0 0.05040095 0 0.05040105 1 0.05049995 1
+ 0.05050005 0 0.05055095 0 0.05055105 1 0.05064995 1 0.05065005 0 0.05075095 0
+ 0.05075105 1 0.05084995 1 0.05085005 0 0.05095095 0 0.05095105 1 0.05099995 1
+ 0.05100005 0 0.05110095 0 0.05110105 1 0.05114995 1 0.05115005 0 0.0512 0
+ )
Bswa1 pos ya1 I=V(pos,ya1)*1e-6*exp(18.42068074395*V(ga1))
Bdrift ya1 zshift V=0.05
Rdrift zshift xa1 0.0102
Dsa1 xa1 pa transistorD
Daa1 pa pos antiparallelD
Bswa2 0 ya2 I=V(0,ya2)*1e-6*exp(18.42068074395*V(ga2))
Rwirea2 ya2 xa2 0.01
Dsa2 xa2 ma transistorD
Daa2 ma 0 antiparallelD
Bswa3 pa ya3 I=V(pa,ya3)*1e-6*exp(18.42068074395*V(ga3))
Rwirea3 ya3 xa3 0.01
Dsa3 xa3 ma transistorD
Daa3 ma pa antiparallelD
Bswa4 pa ya4 I=V(pa,ya4)*1e-6*exp(18.42068074395*V(ga4))
Rwirea4 ya4 xa4 0.01
Dsa4 xa4 neg transistorD
Daa4 neg pa antiparallelD
La pa ra 0.002 IC=0
Ra ra ea 0.25
Bemfa ea neutral V=20*sin(2*pi*25*time+(0)*pi/180)*min(time/1e-6,1)
Vgb1 gb1 0 PWL(
+ 0 0 0.00030095 0 0.00030105 1 0.00044995 1 0.00045005 0 0.00215095 0
+ 0.00215105 1 0.00224995 1 0.00225005 0 0.00230095 0 0.00230105 1 0.00239995 1
+ 0.00240005 0 0.00245095 0 0.00245105 1 0.00259995 1 0.00260005 0 0.00265095 0
+ 0.00265105 1 0.00274995 1 0.00275005 0 0.00335095 0 0.00335105 1 0.00339995 1
+ 0.00340005 0 0.00350095 0 0.00350105 1 0.00359995 1 0.00360005 0 0.00365095 0
+ 0.00365105 1 0.00374995 1 0.00375005 0 0.00385095 0 0.00385105 1 0.00389995 1
+ 0.00390005 0 0.00400095 0 0.00400105 1 0.00404995 1 0.00405005 0 0.00410095 0
+ 0.00410105 1 0.00414995 1 0.00415005 0 0.00425095 0 0.00425105 1 0.00429995 1
+ 0.00430005 0 0.00440095 0 0.00440105 1 0.00449995 1 0.00450005 0 0.00455095 0
+ 0.00455105 1 0.00459995 1 0.00460005 0 0.00465095 0 0.00465105 1 0.00474995 1
+ 0.00475005 0 0.00485095 0 0.00485105 1 0.00489995 1 0.00490005 0 0.00500095 0
+ 0.00500105 1 0.00504995 1 0.00505005 0 0.00510095 0 0.00510105 1 0.00514995 1
+ 0.00515005 0 0.00525095 0 0.00525105 1 0.00534995 1 0.00535005 0 0.00545095 0
+ 0.00545105 1 0.00549995 1 0.00550005 0 0.00555095 0 0.00555105 1 0.00559995 1
+ 0.00560005 0 0.00570095 0 0.00570105 1 0.00579995 1 0.00580005 0 0.00585095 0
+ 0.00585105 1 0.00589995 1 0.00590005 0 0.00595095 0 0.00595105 1 0.00604995 1
+ 0.00605005 0 0.00615095 0 0.00615105 1 0.00619995 1 0.00620005 0 0.00625095 0
+ 0.00625105 1 0.00634995 1 0.00635005 0 0.00645095 0 0.00645105 1 0.00649995 1
+ 0.00650005 0 0.00655095 0 0.00655105 1 0.00659995 1 0.00660005 0 0.00755095 0
+ 0.00755105 1 0.00764995 1 0.00765005 0 0.00770095 0 0.00770105 1 0.00774995 1
+ 0.00775005 0 0.00800095 0 0.00800105 1 0.00809995 1 0.00810005 0 0.00815095 0
+ 0.00815105 1 0.00819995 1 0.00820005 0 0.00940095 0 0.00940105 1 0.00944995 1
+ 0.00945005 0 0.00955095 0 0.00955105 1 0.00959995 1 0.00960005 0 0.01000095 0
+ 0.01000105 1 0.01009995 1 0.01010005 0 0.01015095 0 0.01015105 1 0.01029995 1
+ 0.01030005 0 0.01185095 0 0.01185105 1 0.01189995 1 0.01190005 0 0.01255095 0
+ 0.01255105 1 0.01269995 1 0.01270005 0 0.01310095 0 0.01310105 1 0.01329995 1
+ 0.01330005 0 0.01340095 0 0.01340105 1 0.01369995 1 0.01370005 0 0.01380095 0
+ 0.01380105 1 0.01384995 1 0.01385005 0 0.01420095 0 0.01420105 1 0.01439995 1
+ 0.01440005 0 0.01445095 0 0.01445105 1 0.01449995 1 0.01450005 0 0.01465095 0
+ 0.01465105 1 0.01469995 1 0.01470005 0 0.01520095 0 0.01520105 1 0.01529995 1
+ 0.01530005 0 0.01535095 0 0.01535105 1 0.01609995 1 0.01610005 0 0.01695095 0
+ 0.01695105 1 0.01704995 1 0.01705005 0 0.01710095 0 0.01710105 1 0.01744995 1
+ 0.01745005 0 0.01750095 0 0.01750105 1 0.01759995 1 0.01760005 0 0.01765095 0
+ 0.01765105 1 0.01774995 1 0.01775005 0 0.01780095 0 0.01780105 1 0.01784995 1
+ 0.01785005 0 0.01790095 0 0.01790105 1 0.01799995 1 0.01800005 0 0.01805095 0
+ 0.01805105 1 0.01814995 1 0.01815005 0 0.01820095 0 0.01820105 1 0.01839995 1
+ 0.01840005 0 0.01845095 0 0.01845105 1 0.01884995 1 0.01885005 0 0.01890095 0
+ 0.01890105 1 0.01909995 1 0.01910005 0 0.01915095 0 0.01915105 1 0.01924995 1
+ 0.01925005 0 0.01930095 0 0.01930105 1 0.01934995 1 0.01935005 0 0.01940095 0
+ 0.01940105 1 0.01954995 1 0.01955005 0 0.01995095 0 0.01995105 1 0.02019995 1
+ 0.02020005 0 0.02025095 0 0.02025105 1 0.02049995 1 0.02050005 0 0.02055095 0
+ 0.02055105 1 0.02059995 1 0.02060005 0 0.02065095 0 0.02065105 1 0.02089995 1
+ 0.02090005 0 0.02155095 0 0.02155105 1 0.02159995 1 0.02160005 0 0.02180095 0
+ 0.02180105 1 0.02224995 1 0.02225005 0 0.02230095 0 0.02230105 1 0.02234995 1
+ 0.02235005 0 0.02245095 0 0.02245105 1 0.02249995 1 0.02250005 0 0.02755095 0
+ 0.02755105 1 0.02759995 1 0.02760005 0 0.02765095 0 0.02765105 1 0.02804995 1
+ 0.02805005 0 0.02815095 0 0.02815105 1 0.02819995 1 0.02820005 0 0.02825095 0
+ 0.02825105 1 0.02884995 1 0.02885005 0 0.02890095 0 0.02890105 1 0.02894995 1
+ 0.02895005 0 0.02920095 0 0.02920105 1 0.02924995 1 0.02925005 0 0.02935095 0
+ 0.02935105 1 0.02944995 1 0.02945005 0 0.02950095 0 0.02950105 1 0.02974995 1
+ 0.02975005 0 0.02980095 0 0.02980105 1 0.02989995 1 0.02990005 0 0.02995095 0
+ 0.02995105 1 0.02999995 1 0.03000005 0 0.03005095 0 0.03005105 1 0.03014995 1
+ 0.03015005 0 0.03020095 0 0.03020105 1 0.03029995 1 0.03030005 0 0.03050095 0
+ 0.03050105 1 0.03079995 1 0.03080005 0 0.03110095 0 0.03110105 1 0.03119995 1
+ 0.03120005 0 0.03125095 0 0.03125105 1 0.03129995 1 0.03130005 0 0.03135095 0
+ 0.03135105 1 0.03144995 1 0.03145005 0 0.03150095 0 0.03150105 1 0.03159995 1
+ 0.03160005 0 0.03165095 0 0.03165105 1 0.03169995 1 0.03170005 0 0.03175095 0
+ 0.03175105 1 0.03184995 1 0.03185005 0 0.03190095 0 0.03190105 1 0.03204995 1
+ 0.03205005 0 0.03210095 0 0.03210105 1 0.03214995 1 0.03215005 0 0.03220095 0
+ 0.03220105 1 0.03229995 1 0.03230005 0 0.03235095 0 0.03235105 1 0.03239995 1
+ 0.03240005 0 0.03245095 0 0.03245105 1 0.03269995 1 0.03270005 0 0.03275095 0
+ 0.03275105 1 0.03284995 1 0.03285005 0 0.03290095 0 0.03290105 1 0.03299995 1
+ 0.03300005 0 0.03305095 0 0.03305105 1 0.03314995 1 0.03315005 0 0.03320095 0
+ 0.03320105 1 0.03324995 1 0.03325005 0 0.03330095 0 0.03330105 1 0.03344995 1
+ 0.03345005 0 0.03350095 0 0.03350105 1 0.03354995 1 0.03355005 0 0.03360095 0
+ 0.03360105 1 0.03374995 1 0.03375005 0 0.03390095 0 0.03390105 1 0.03399995 1
+ 0.03400005 0 0.03405095 0 0.03405105 1 0.03414995 1 0.03415005 0 0.03470095 0
+ 0.03470105 1 0.03474995 1 0.03475005 0 0.03925095 0 0.03925105 1 0.03939995 1
+ 0.03940005 0 0.03955095 0 0.03955105 1 0.03964995 1 0.03965005 0 0.04150095 0
+ 0.04150105 1 0.04159995 1 0.04160005 0 0.04165095 0 0.04165105 1 0.04174995 1
+ 0.04175005 0 0.04180095 0 0.04180105 1 0.04189995 1 0.04190005 0 0.04245095 0
+ 0.04245105 1 0.04254995 1 0.04255005 0 0.04260095 0 0.04260105 1 0.04269995 1
+ 0.04270005 0 0.04280095 0 0.04280105 1 0.04289995 1 0.04290005 0 0.04295095 0
+ 0.04295105 1 0.04304995 1 0.04305005 0 0.04315095 0 0.04315105 1 0.04319995 1
+ 0.04320005 0 0.04330095 0 0.04330105 1 0.04339995 1 0.04340005 0 0.04345095 0
+ 0.04345105 1 0.04354995 1 0.04355005 0 0.04370095 0 0.04370105 1 0.04379995 1
+ 0.04380005 0 0.04390095 0 0.04390105 1 0.04399995 1 0.04400005 0 0.04405095 0
+ 0.04405105 1 0.04414995 1 0.04415005 0 0.04425095 0 0.04425105 1 0.04429995 1
+ 0.04430005 0 0.04435095 0 0.04435105 1 0.04439995 1 0.04440005 0 0.04450095 0
+ 0.04450105 1 0.04459995 1 0.04460005 0 0.04465095 0 0.04465105 1 0.04474995 1
+ 0.04475005 0 0.04485095 0 0.04485105 1 0.04489995 1 0.04490005 0 0.04495095 0
+ 0.04495105 1 0.04504995 1 0.04505005 0 0.04510095 0 0.04510105 1 0.04519995 1
+ 0.04520005 0 0.04525095 0 0.04525105 1 0.04529995 1 0.04530005 0 0.04540095 0
+ 0.04540105 1 0.04549995 1 0.04550005 0 0.04560095 0 0.04560105 1 0.04564995 1
+ 0.04565005 0 0.04570095 0 0.04570105 1 0.04579995 1 0.04580005 0 0.04585095 0
+ 0.04585105 1 0.04594995 1 0.04595005 0 0.04600095 0 0.04600105 1 0.04604995 1
+ 0.04605005 0 0.04615095 0 0.04615105 1 0.04624995 1 0.04625005 0 0.04630095 0
+ 0.04630105 1 0.04634995 1 0.04635005 0 0.04645095 0 0.04645105 1 0.04654995 1
+ 0.04655005 0 0.04660095 0 0.04660105 1 0.04664995 1 0.04665005 0 0.04680095 0
+ 0.04680105 1 0.04684995 1 0.04685005 0 0.04690095 0 0.04690105 1 0.04699995 1
+ 0.04700005 0 0.04720095 0 0.04720105 1 0.04729995 1 0.04730005 0 0.04735095 0
+ 0.04735105 1 0.04739995 1 0.04740005 0 0.0512 0
+ )
Vgb2 gb2 0 PWL(
+ 0 1 5e-08 0 0.00020095 0 0.00020105 1 0.00054995 1 0.00055005 0
+ 0.00060095 0 0.00060105 1 0.00064995 1 0.00065005 0 0.00090095 0 0.00090105 1
+ 0.00109995 1 0.00110005 0 0.00135095 0 0.00135105 1 0.00154995 1 0.00155005 0
+ 0.00195095 0 0.00195105 1 0.00284995 1 0.00285005 0 0.00295095 0 0.00295105 1
+ 0.00299995 1 0.00300005 0 0.00330095 0 0.00330105 1 0.00669995 1 0.00670005 0
+ 0.00695095 0 0.00695105 1 0.00699995 1 0.00700005 0 0.00740095 0 0.00740105 1
+ 0.00744995 1 0.00745005 0 0.00750095 0 0.00750105 1 0.00789995 1 0.00790005 0
+ 0.00795095 0 0.00795105 1 0.00844995 1 0.00845005 0 0.00920095 0 0.00920105 1
+ 0.00924995 1 0.00925005 0 0.00935095 0 0.00935105 1 0.00984995 1 0.00985005 0
+ 0.00995095 0 0.00995105 1 0.01039995 1 0.01040005 0 0.01050095 0 0.01050105 1
+ 0.01054995 1 0.01055005 0 0.01065095 0 0.01065105 1 0.01069995 1 0.01070005 0
+ 0.01075095 0 0.01075105 1 0.01079995 1 0.01080005 0 0.01090095 0 0.01090105 1
+ 0.01094995 1 0.01095005 0 0.01105095 0 0.01105105 1 0.01109995 1 0.01110005 0
+ 0.01135095 0 0.01135105 1 0.01139995 1 0.01140005 0 0.01145095 0 0.01145105 1
+ 0.01149995 1 0.01150005 0 0.01165095 0 0.01165105 1 0.01169995 1 0.01170005 0
+ 0.01180095 0 0.01180105 1 0.01194995 1 0.01195005 0 0.01205095 0 0.01205105 1
+ 0.01209995 1 0.01210005 0 0.01215095 0 0.01215105 1 0.01219995 1 0.01220005 0
+ 0.01230095 0 0.01230105 1 0.01234995 1 0.01235005 0 0.01250095 0 0.01250105 1
+ 0.01279995 1 0.01280005 0 0.01285095 0 0.01285105 1 0.01289995 1 0.01290005 0
+ 0.01305095 0 0.01305105 1 0.01389995 1 0.01390005 0 0.01405095 0 0.01405105 1
+ 0.01474995 1 0.01475005 0 0.01485095 0 0.01485105 1 0.01489995 1 0.01490005 0
+ 0.01500095 0 0.01500105 1 0.01614995 1 0.01615005 0 0.01620095 0 0.01620105 1
+ 0.01629995 1 0.01630005 0 0.01635095 0 0.01635105 1 0.01644995 1 0.01645005 0
+ 0.01655095 0 0.01655105 1 0.01659995 1 0.01660005 0 0.01670095 0 0.01670105 1
+ 0.01674995 1 0.01675005 0 0.01685095 0 0.01685105 1 0.01964995 1 0.01965005 0
+ 0.01975095 0 0.01975105 1 0.01979995 1 0.01980005 0 0.01985095 0 0.01985105 1
+ 0.02094995 1 0.02095005 0 0.02100095 0 0.02100105 1 0.02104995 1 0.02105005 0
+ 0.02115095 0 0.02115105 1 0.02119995 1 0.02120005 0 0.02130095 0 0.02130105 1
+ 0.02134995 1 0.02135005 0 0.02145095 0 0.02145105 1 0.02164995 1 0.02165005 0
+ 0.02170095 0 0.02170105 1 0.02274995 1 0.02275005 0 0.02280095 0 0.02280105 1
+ 0.02284995 1 0.02285005 0 0.02295095 0 0.02295105 1 0.02299995 1 0.02300005 0
+ 0.02310095 0 0.02310105 1 0.02319995 1 0.02320005 0 0.02325095 0 0.02325105 1
+ 0.02334995 1 0.02335005 0 0.02340095 0 0.02340105 1 0.02354995 1 0.02355005 0
+ 0.02365095 0 0.02365105 1 0.02369995 1 0.02370005 0 0.02380095 0 0.02380105 1
+ 0.02389995 1 0.02390005 0 0.02395095 0 0.02395105 1 0.02404995 1 0.02405005 0
+ 0.02410095 0 0.02410105 1 0.02419995 1 0.02420005 0 0.02425095 0 0.02425105 1
+ 0.02429995 1 0.02430005 0 0.02435095 0 0.02435105 1 0.02444995 1 0.02445005 0
+ 0.02455095 0 0.02455105 1 0.02459995 1 0.02460005 0 0.02465095 0 0.02465105 1
+ 0.02469995 1 0.02470005 0 0.02480095 0 0.02480105 1 0.02484995 1 0.02485005 0
+ 0.02495095 0 0.02495105 1 0.02504995 1 0.02505005 0 0.02510095 0 0.02510105 1
+ 0.02514995 1 0.02515005 0 0.02520095 0 0.02520105 1 0.02529995 1 0.02530005 0
+ 0.02535095 0 0.02535105 1 0.02544995 1 0.02545005 0 0.02550095 0 0.02550105 1
+ 0.02554995 1 0.02555005 0 0.02565095 0 0.02565105 1 0.02569995 1 0.02570005 0
+ 0.02575095 0 0.02575105 1 0.02579995 1 0.02580005 0 0.02590095 0 0.02590105 1
+ 0.02599995 1 0.02600005 0 0.02605095 0 0.02605105 1 0.02609995 1 0.02610005 0
+ 0.02615095 0 0.02615105 1 0.02624995 1 0.02625005 0 0.02635095 0 0.02635105 1
+ 0.02639995 1 0.02640005 0 0.02645095 0 0.02645105 1 0.02654995 1 0.02655005 0
+ 0.02660095 0 0.02660105 1 0.02664995 1 0.02665005 0 0.02675095 0 0.02675105 1
+ 0.02679995 1 0.02680005 0 0.02685095 0 0.02685105 1 0.02694995 1 0.02695005 0
+ 0.02705095 0 0.02705105 1 0.02709995 1 0.02710005 0 0.02715095 0 0.02715105 1
+ 0.02724995 1 0.02725005 0 0.02730095 0 0.02730105 1 0.02734995 1 0.02735005 0
+ 0.02745095 0 0.02745105 1 0.03034995 1 0.03035005 0 0.03040095 0 0.03040105 1
+ 0.03084995 1 0.03085005 0 0.03100095 0 0.03100105 1 0.03379995 1 0.03380005 0
+ 0.03385095 0 0.03385105 1 0.03419995 1 0.03420005 0 0.03455095 0 0.03455105 1
+ 0.03479995 1 0.03480005 0 0.03550095 0 0.03550105 1 0.03554995 1 0.03555005 0
+ 0.03565095 0 0.03565105 1 0.03589995 1 0.03590005 0 0.03600095 0 0.03600105 1
+ 0.03604995 1 0.03605005 0 0.03615095 0 0.03615105 1 0.03619995 1 0.03620005 0
+ 0.03630095 0 0.03630105 1 0.03634995 1 0.03635005 0 0.03665095 0 0.03665105 1
+ 0.03669995 1 0.03670005 0 0.03680095 0 0.03680105 1 0.03684995 1 0.03685005 0
+ 0.03705095 0 0.03705105 1 0.03709995 1 0.03710005 0 0.03720095 0 0.03720105 1
+ 0.03724995 1 0.03725005 0 0.03755095 0 0.03755105 1 0.03759995 1 0.03760005 0
+ 0.03780095 0 0.03780105 1 0.03784995 1 0.03785005 0 0.03840095 0 0.03840105 1
+ 0.03844995 1 0.03845005 0 0.03895095 0 0.03895105 1 0.03899995 1 0.03900005 0
+ 0.03915095 0 0.03915105 1 0.03974995 1 0.03975005 0 0.04000095 0 0.04000105 1
+ 0.04004995 1 0.04005005 0 0.04010095 0 0.04010105 1 0.04014995 1 0.04015005 0
+ 0.04045095 0 0.04045105 1 0.04059995 1 0.04060005 0 0.04085095 0 0.04085105 1
+ 0.04104995 1 0.04105005 0 0.04130095 0 0.04130105 1 0.04199995 1 0.04200005 0
+ 0.04210095 0 0.04210105 1 0.04219995 1 0.04220005 0 0.04225095 0 0.04225105 1
+ 0.04709995 1 0.04710005 0 0.04715095 0 0.04715105 1 0.04754995 1 0.04755005 0
+ 0.04795095 0 0.04795105 1 0.04799995 1 0.04800005 0 0.04810095 0 0.04810105 1
+ 0.04814995 1 0.04815005 0 0.04860095 0 0.04860105 1 0.04864995 1 0.04865005 0
+ 0.04875095 0 0.04875105 1 0.04894995 1 0.04895005 0 0.04905095 0 0.04905105 1
+ 0.04909995 1 0.04910005 0 0.04940095 0 0.04940105 1 0.04944995 1 0.04945005 0
+ 0.04975095 0 0.04975105 1 0.04979995 1 0.04980005 0 0.05010095 0 0.05010105 1
+ 0.05014995 1 0.05015005 0 0.05020095 0 0.05020105 1 0.05024995 1 0.05025005 0
+ 0.05035095 0 0.05035105 1 0.05039995 1 0.05040005 0 0.05070095 0 0.05070105 1
+ 0.05074995 1 0.05075005 0 0.05090095 0 0.05090105 1 0.05094995 1 0.05095005 0
+ 0.05100095 0 0.05100105 1 0.05104995 1 0.05105005 0 0.05115095 0 0.05115105 1
+ 0.0512 1
+ )
Vgb3 gb3 0 PWL(
+ 0 1 0.00029995 1 0.00030005 0 0.00045095 0 0.00045105 1 0.00214995 1
+ 0.00215005 0 0.00225095 0 0.00225105 1 0.00229995 1 0.00230005 0 0.00240095 0
+ 0.00240105 1 0.00244995 1 0.00245005 0 0.00260095 0 0.00260105 1 0.00264995 1
+ 0.00265005 0 0.00275095 0 0.00275105 1 0.00334995 1 0.00335005 0 0.00340095 0
+ 0.00340105 1 0.00349995 1 0.00350005 0 0.00360095 0 0.00360105 1 0.00364995 1
+ 0.00365005 0 0.00375095 0 0.00375105 1 0.00384995 1 0.00385005 0 0.00390095 0
+ 0.00390105 1 0.00399995 1 0.00400005 0 0.00405095 0 0.00405105 1 0.00409995 1
+ 0.00410005 0 0.00415095 0 0.00415105 1 0.00424995 1 0.00425005 0 0.00430095 0
+ 0.00430105 1 0.00439995 1 0.00440005 0 0.00450095 0 0.00450105 1 0.00454995 1
+ 0.00455005 0 0.00460095 0 0.00460105 1 0.00464995 1 0.00465005 0 0.00475095 0
+ 0.00475105 1 0.00484995 1 0.00485005 0 0.00490095 0 0.00490105 1 0.00499995 1
+ 0.00500005 0 0.00505095 0 0.00505105 1 0.00509995 1 0.00510005 0 0.00515095 0
+ 0.00515105 1 0.00524995 1 0.00525005 0 0.00535095 0 0.00535105 1 0.00544995 1
+ 0.00545005 0 0.00550095 0 0.00550105 1 0.00554995 1 0.00555005 0 0.00560095 0
+ 0.00560105 1 0.00569995 1 0.00570005 0 0.00580095 0 0.00580105 1 0.00584995 1
+ 0.00585005 0 0.00590095 0 0.00590105 1 0.00594995 1 0.00595005 0 0.00605095 0
+ 0.00605105 1 0.00614995 1 0.00615005 0 0.00620095 0 0.00620105 1 0.00624995 1
+ 0.00625005 0 0.00635095 0 0.00635105 1 0.00644995 1 0.00645005 0 0.00650095 0
+ 0.00650105 1 0.00654995 1 0.00655005 0 0.00660095 0 0.00660105 1 0.00754995 1
+ 0.00755005 0 0.00765095 0 0.00765105 1 0.00769995 1 0.00770005 0 0.00775095 0
+ 0.00775105 1 0.00799995 1 0.00800005 0 0.00810095 0 0.00810105 1 0.00814995 1
+ 0.00815005 0 0.00820095 0 0.00820105 1 0.00939995 1 0.00940005 0 0.00945095 0
+ 0.00945105 1 0.00954995 1 0.00955005 0 0.00960095 0 0.00960105 1 0.00999995 1
+ 0.01000005 0 0.01010095 0 0.01010105 1 0.01014995 1 0.01015005 0 0.01030095 0
+ 0.01030105 1 0.01184995 1 0.01185005 0 0.01190095 0 0.01190105 1 0.01254995 1
+ 0.01255005 0 0.01270095 0 0.01270105 1 0.01309995 1 0.01310005 0 0.01330095 0
+ 0.01330105 1 0.01339995 1 0.01340005 0 0.01370095 0 0.01370105 1 0.01379995 1
+ 0.01380005 0 0.01385095 0 0.01385105 1 0.01419995 1 0.01420005 0 0.01440095 0
+ 0.01440105 1 0.01444995 1 0.01445005 0 0.01450095 0 0.01450105 1 0.01464995 1
+ 0.01465005 0 0.01470095 0 0.01470105 1 0.01519995 1 0.01520005 0 0.01530095 0
+ 0.01530105 1 0.01534995 1 0.01535005 0 0.01610095 0 0.01610105 1 0.01694995 1
+ 0.01695005 0 0.01705095 0 0.01705105 1 0.01709995 1 0.01710005 0 0.01745095 0
+ 0.01745105 1 0.01749995 1 0.01750005 0 0.01760095 0 0.01760105 1 0.01764995 1
+ 0.01765005 0 0.01775095 0 0.01775105 1 0.01779995 1 0.01780005 0 0.01785095 0
+ 0.01785105 1 0.01789995 1 0.01790005 0 0.01800095 0 0.01800105 1 0.01804995 1
+ 0.01805005 0 0.01815095 0 0.01815105 1 0.01819995 1 0.01820005 0 0.01840095 0
+ 0.01840105 1 0.01844995 1 0.01845005 0 0.01885095 0 0.01885105 1 0.01889995 1
+ 0.01890005 0 0.01910095 0 0.01910105 1 0.01914995 1 0.01915005 0 0.01925095 0
+ 0.01925105 1 0.01929995 1 0.01930005 0 0.01935095 0 0.01935105 1 0.01939995 1
+ 0.01940005 0 0.01955095 0 0.01955105 1 0.01994995 1 0.01995005 0 0.02020095 0
+ 0.02020105 1 0.02024995 1 0.02025005 0 0.02050095 0 0.02050105 1 0.02054995 1
+ 0.02055005 0 0.02060095 0 0.02060105 1 0.02064995 1 0.02065005 0 0.02090095 0
+ 0.02090105 1 0.02154995 1 0.02155005 0 0.02160095 0 0.02160105 1 0.02179995 1
+ 0.02180005 0 0.02225095 0 0.02225105 1 0.02229995 1 0.02230005 0 0.02235095 0
+ 0.02235105 1 0.02244995 1 0.02245005 0 0.02250095 0 0.02250105 1 0.02754995 1
+ 0.02755005 0 0.02760095 0 0.02760105 1 0.02764995 1 0.02765005 0 0.02805095 0
+ 0.02805105 1 0.02814995 1 0.02815005 0 0.02820095 0 0.02820105 1 0.02824995 1
+ 0.02825005 0 0.02885095 0 0.02885105 1 0.02889995 1 0.02890005 0 0.02895095 0
+ 0.02895105 1 0.02919995 1 0.02920005 0 0.02925095 0 0.02925105 1 0.02934995 1
+ 0.02935005 0 0.02945095 0 0.02945105 1 0.02949995 1 0.02950005 0 0.02975095 0
+ 0.02975105 1 0.02979995 1 0.02980005 0 0.02990095 0 0.02990105 1 0.02994995 1
+ 0.02995005 0 0.03000095 0 0.03000105 1 0.03004995 1 0.03005005 0 0.03015095 0
+ 0.03015105 1 0.03019995 1 0.03020005 0 0.03030095 0 0.03030105 1 0.03049995 1
+ 0.03050005 0 0.03080095 0 0.03080105 1 0.03109995 1 0.03110005 0 0.03120095 0
+ 0.03120105 1 0.03124995 1 0.03125005 0 0.03130095 0 0.03130105 1 0.03134995 1
+ 0.03135005 0 0.03145095 0 0.03145105 1 0.03149995 1 0.03150005 0 0.03160095 0
+ 0.03160105 1 0.03164995 1 0.03165005 0 0.03170095 0 0.03170105 1 0.03174995 1
+ 0.03175005 0 0.03185095 0 0.03185105 1 0.03189995 1 0.03190005 0 0.03205095 0
+ 0.03205105 1 0.03209995 1 0.03210005 0 0.03215095 0 0.03215105 1 0.03219995 1
+ 0.03220005 0 0.03230095 0 0.03230105 1 0.03234995 1 0.03235005 0 0.03240095 0
+ 0.03240105 1 0.03244995 1 0.03245005 0 0.03270095 0 0.03270105 1 0.03274995 1
+ 0.03275005 0 0.03285095 0 0.03285105 1 0.03289995 1 0.03290005 0 0.03300095 0
+ 0.03300105 1 0.03304995 1 0.03305005 0 0.03315095 0 0.03315105 1 0.03319995 1
+ 0.03320005 0 0.03325095 0 0.03325105 1 0.03329995 1 0.03330005 0 0.03345095 0
+ 0.03345105 1 0.03349995 1 0.03350005 0 0.03355095 0 0.03355105 1 0.03359995 1
+ 0.03360005 0 0.03375095 0 0.03375105 1 0.03389995 1 0.03390005 0 0.03400095 0
+ 0.03400105 1 0.03404995 1 0.03405005 0 0.03415095 0 0.03415105 1 0.03469995 1
+ 0.03470005 0 0.03475095 0 0.03475105 1 0.03924995 1 0.03925005 0 0.03940095 0
+ 0.03940105 1 0.03954995 1 0.03955005 0 0.03965095 0 0.03965105 1 0.04149995 1
+ 0.04150005 0 0.04160095 0 0.04160105 1 0.04164995 1 0.04165005 0 0.04175095 0
+ 0.04175105 1 0.04179995 1 0.04180005 0 0.04190095 0 0.04190105 1 0.04244995 1
+ 0.04245005 0 0.04255095 0 0.04255105 1 0.04259995 1 0.04260005 0 0.04270095 0
+ 0.04270105 1 0.04279995 1 0.04280005 0 0.04290095 0 0.04290105 1 0.04294995 1
+ 0.04295005 0 0.04305095 0 0.04305105 1 0.04314995 1 0.04315005 0 0.04320095 0
+ 0.04320105 1 0.04329995 1 0.04330005 0 0.04340095 0 0.04340105 1 0.04344995 1
+ 0.04345005 0 0.04355095 0 0.04355105 1 0.04369995 1 0.04370005 0 0.04380095 0
+ 0.04380105 1 0.04389995 1 0.04390005 0 0.04400095 0 0.04400105 1 0.04404995 1
+ 0.04405005 0 0.04415095 0 0.04415105 1 0.04424995 1 0.04425005 0 0.04430095 0
+ 0.04430105 1 0.04434995 1 0.04435005 0 0.04440095 0 0.04440105 1 0.04449995 1
+ 0.04450005 0 0.04460095 0 0.04460105 1 0.04464995 1 0.04465005 0 0.04475095 0
+ 0.04475105 1 0.04484995 1 0.04485005 0 0.04490095 0 0.04490105 1 0.04494995 1
+ 0.04495005 0 0.04505095 0 0.04505105 1 0.04509995 1 0.04510005 0 0.04520095 0
+ 0.04520105 1 0.04524995 1 0.04525005 0 0.04530095 0 0.04530105 1 0.04539995 1
+ 0.04540005 0 0.04550095 0 0.04550105 1 0.04559995 1 0.04560005 0 0.04565095 0
+ 0.04565105 1 0.04569995 1 0.04570005 0 0.04580095 0 0.04580105 1 0.04584995 1
+ 0.04585005 0 0.04595095 0 0.04595105 1 0.04599995 1 0.04600005 0 0.04605095 0
+ 0.04605105 1 0.04614995 1 0.04615005 0 0.04625095 0 0.04625105 1 0.04629995 1
+ 0.04630005 0 0.04635095 0 0.04635105 1 0.04644995 1 0.04645005 0 0.04655095 0
+ 0.04655105 1 0.04659995 1 0.04660005 0 0.04665095 0 0.04665105 1 0.04679995 1
+ 0.04680005 0 0.04685095 0 0.04685105 1 0.04689995 1 0.04690005 0 0.04700095 0
+ 0.04700105 1 0.04719995 1 0.04720005 0 0.04730095 0 0.04730105 1 0.04734995 1
+ 0.04735005 0 0.04740095 0 0.04740105 1 0.0512 1
+ )
Vgb4 gb4 0 PWL(
+ 0 0 9.5e-07 0 1.05e-06 1 0.00019995 1 0.00020005 0 0.00055095 0
+ 0.00055105 1 0.00059995 1 0.00060005 0 0.00065095 0 0.00065105 1 0.00089995 1
+ 0.00090005 0 0.00110095 0 0.00110105 1 0.00134995 1 0.00135005 0 0.00155095 0
+ 0.00155105 1 0.00194995 1 0.00195005 0 0.00285095 0 0.00285105 1 0.00294995 1
+ 0.00295005 0 0.00300095 0 0.00300105 1 0.00329995 1 0.00330005 0 0.00670095 0
+ 0.00670105 1 0.00694995 1 0.00695005 0 0.00700095 0 0.00700105 1 0.00739995 1
+ 0.00740005 0 0.00745095 0 0.00745105 1 0.00749995 1 0.00750005 0 0.00790095 0
+ 0.00790105 1 0.00794995 1 0.00795005 0 0.00845095 0 0.00845105 1 0.00919995 1
+ 0.00920005 0 0.00925095 0 0.00925105 1 0.00934995 1 0.00935005 0 0.00985095 0
+ 0.00985105 1 0.00994995 1 0.00995005 0 0.01040095 0 0.01040105 1 0.01049995 1
+ 0.01050005 0 0.01055095 0 0.01055105 1 0.01064995 1 0.01065005 0 0.01070095 0
+ 0.01070105 1 0.01074995 1 0.01075005 0 0.01080095 0 0.01080105 1 0.01089995 1
+ 0.01090005 0 0.01095095 0 0.01095105 1 0.01104995 1 0.01105005 0 0.01110095 0
+ 0.01110105 1 0.01134995 1 0.01135005 0 0.01140095 0 0.01140105 1 0.01144995 1
+ 0.01145005 0 0.01150095 0 0.01150105 1 0.01164995 1 0.01165005 0 0.01170095 0
+ 0.01170105 1 0.01179995 1 0.01180005 0 0.01195095 0 0.01195105 1 0.01204995 1
+ 0.01205005 0 0.01210095 0 0.01210105 1 0.01214995 1 0.01215005 0 0.01220095 0
+ 0.01220105 1 0.01229995 1 0.01230005 0 0.01235095 0 0.01235105 1 0.01249995 1
+ 0.01250005 0 0.01280095 0 0.01280105 1 0.01284995 1 0.01285005 0 0.01290095 0
+ 0.01290105 1 0.01304995 1 0.01305005 0 0.01390095 0 0.01390105 1 0.01404995 1
+ 0.01405005 0 0.01475095 0 0.01475105 1 0.01484995 1 0.01485005 0 0.01490095 0
+ 0.01490105 1 0.01499995 1 0.01500005 0 0.01615095 0 0.01615105 1 0.01619995 1
+ 0.01620005 0 0.01630095 0 0.01630105 1 0.01634995 1 0.01635005 0 0.01645095 0
+ 0.01645105 1 0.01654995 1 0.01655005 0 0.01660095 0 0.01660105 1 0.01669995 1
+ 0.01670005 0 0.01675095 0 0.01675105 1 0.01684995 1 0.01685005 0 0.01965095 0
+ 0.01965105 1 0.01974995 1 0.01975005 0 0.01980095 0 0.01980105 1 0.01984995 1
+ 0.01985005 0 0.02095095 0 0.02095105 1 0.02099995 1 0.02100005 0 0.02105095 0
+ 0.02105105 1 0.02114995 1 0.02115005 0 0.02120095 0 0.02120105 1 0.02129995 1
+ 0.02130005 0 0.02135095 0 0.02135105 1 0.02144995 1 0.02145005 0 0.02165095 0
+ 0.02165105 1 0.02169995 1 0.02170005 0 0.02275095 0 0.02275105 1 0.02279995 1
+ 0.02280005 0 0.02285095 0 0.02285105 1 0.02294995 1 0.02295005 0 0.02300095 0
+ 0.02300105 1 0.02309995 1 0.02310005 0 0.02320095 0 0.02320105 1 0.02324995 1
+ 0.02325005 0 0.02335095 0 0.02335105 1 0.02339995 1 0.02340005 0 0.02355095 0
+ 0.02355105 1 0.02364995 1 0.02365005 0 0.02370095 0 0.02370105 1 0.02379995 1
+ 0.02380005 0 0.02390095 0 0.02390105 1 0.02394995 1 0.02395005 0 0.02405095 0
+ 0.02405105 1 0.02409995 1 0.02410005 0 0.02420095 0 0.02420105 1 0.02424995 1
+ 0.02425005 0 0.02430095 0 0.02430105 1 0.02434995 1 0.02435005 0 0.02445095 0
+ 0.02445105 1 0.02454995 1 0.02455005 0 0.02460095 0 0.02460105 1 0.02464995 1
+ 0.02465005 0 0.02470095 0 0.02470105 1 0.02479995 1 0.02480005 0 0.02485095 0
+ 0.02485105 1 0.02494995 1 0.02495005 0 0.02505095 0 0.02505105 1 0.02509995 1
+ 0.02510005 0 0.02515095 0 0.02515105 1 0.02519995 1 0.02520005 0 0.02530095 0
+ 0.02530105 1 0.02534995 1 0.02535005 0 0.02545095 0 0.02545105 1 0.02549995 1
+ 0.02550005 0 0.02555095 0 0.02555105 1 0.02564995 1 0.02565005 0 0.02570095 0
+ 0.02570105 1 0.02574995 1 0.02575005 0 0.02580095 0 0.02580105 1 0.02589995 1
+ 0.02590005 0 0.02600095 0 0.02600105 1 0.02604995 1 0.02605005 0 0.02610095 0
+ 0.02610105 1 0.02614995 1 0.02615005 0 0.02625095 0 0.02625105 1 0.02634995 1
+ 0.02635005 0 0.02640095 0 0.02640105 1 0.02644995 1 0.02645005 0 0.02655095 0
+ 0.02655105 1 0.02659995 1 0.02660005 0 0.02665095 0 0.02665105 1 0.02674995 1
+ 0.02675005 0 0.02680095 0 0.02680105 1 0.02684995 1 0.02685005 0 0.02695095 0
+ 0.02695105 1 0.02704995 1 0.02705005 0 0.02710095 0 0.02710105 1 0.02714995 1
+ 0.02715005 0 0.02725095 0 0.02725105 1 0.02729995 1 0.02730005 0 0.02735095 0
+ 0.02735105 1 0.02744995 1 0.02745005 0 0.03035095 0 0.03035105 1 0.03039995 1
+ 0.03040005 0 0.03085095 0 0.03085105 1 0.03099995 1 0.03100005 0 0.03380095 0
+ 0.03380105 1 0.03384995 1 0.03385005 0 0.03420095 0 0.03420105 1 0.03454995 1
+ 0.03455005 0 0.03480095 0 0.03480105 1 0.03549995 1 0.03550005 0 0.03555095 0
+ 0.03555105 1 0.03564995 1 0.03565005 0 0.03590095 0 0.03590105 1 0.03599995 1
+ 0.03600005 0 0.03605095 0 0.03605105 1 0.03614995 1 0.03615005 0 0.03620095 0
+ 0.03620105 1 0.03629995 1 0.03630005 0 0.03635095 0 0.03635105 1 0.03664995 1
+ 0.03665005 0 0.03670095 0 0.03670105 1 0.03679995 1 0.03680005 0 0.03685095 0
+ 0.03685105 1 0.03704995 1 0.03705005 0 0.03710095 0 0.03710105 1 0.03719995 1
+ 0.03720005 0 0.03725095 0 0.03725105 1 0.03754995 1 0.03755005 0 0.03760095 0
+ 0.03760105 1 0.03779995 1 0.03780005 0 0.03785095 0 0.03785105 1 0.03839995 1
+ 0.03840005 0 0.03845095 0 0.03845105 1 0.03894995 1 0.03895005 0 0.03900095 0
+ 0.03900105 1 0.03914995 1 0.03915005 0 0.03975095 0 0.03975105 1 0.03999995 1
+ 0.04000005 0 0.04005095 0 0.04005105 1 0.04009995 1 0.04010005 0 0.04015095 0
+ 0.04015105 1 0.04044995 1 0.04045005 0 0.04060095 0 0.04060105 1 0.04084995 1
+ 0.04085005 0 0.04105095 0 0.04105105 1 0.04129995 1 0.04130005 0 0.04200095 0
+ 0.04200105 1 0.04209995 1 0.04210005 0 0.04220095 0 0.04220105 1 0.04224995 1
+ 0.04225005 0 0.04710095 0 0.04710105 1 0.04714995 1 0.04715005 0 0.04755095 0
+ 0.04755105 1 0.04794995 1 0.04795005 0 0.04800095 0 0.04800105 1 0.04809995 1
+ 0.04810005 0 0.04815095 0 0.04815105 1 0.04859995 1 0.04860005 0 0.04865095 0
+ 0.04865105 1 0.04874995 1 0.04875005 0 0.04895095 0 0.04895105 1 0.04904995 1
+ 0.04905005 0 0.04910095 0 0.04910105 1 0.04939995 1 0.04940005 0 0.04945095 0
+ 0.04945105 1 0.04974995 1 0.04975005 0 0.04980095 0 0.04980105 1 0.05009995 1
+ 0.05010005 0 0.05015095 0 0.05015105 1 0.05019995 1 0.05020005 0 0.05025095 0
+ 0.05025105 1 0.05034995 1 0.05035005 0 0.05040095 0 0.05040105 1 0.05069995 1
+ 0.05070005 0 0.05075095 0 0.05075105 1 0.05089995 1 0.05090005 0 0.05095095 0
+ 0.05095105 1 0.05099995 1 0.05100005 0 0.05105095 0 0.05105105 1 0.05114995 1
+ 0.05115005 0 0.0512 0
+ )
Bswb1 pos yb1 I=V(pos,yb1)*1e-6*exp(18.42068074395*V(gb1))
Rwireb1 yb1 xb1 0.01
Dsb1 xb1 pb transistorD
Dab1 pb pos antiparallelD
Bswb2 0 yb2 I=V(0,yb2)*1e-6*exp(18.42068074395*V(gb2))
Rwireb2 yb2 xb2 0.01
Dsb2 xb2 mb transistorD
Dab2 mb 0 antiparallelD
Bswb3 pb yb3 I=V(pb,yb3)*1e-6*exp(18.42068074395*V(gb3))
Rwireb3 yb3 xb3 0.01
Dsb3 xb3 mb transistorD
Dab3 mb pb antiparallelD
Bswb4 pb yb4 I=V(pb,yb4)*1e-6*exp(18.42068074395*V(gb4))
Rwireb4 yb4 xb4 0.01
Dsb4 xb4 neg transistorD
Dab4 neg pb antiparallelD
Lb pb rb 0.002 IC=0
Rb rb eb 0.25
Bemfb eb neutral V=20*sin(2*pi*25*time+(-120)*pi/180)*min(time/1e-6,1)
Vgc1 gc1 0 PWL(
+ 0 0 9.5e-07 0 1.05e-06 1 0.00019995 1 0.00020005 0 0.00025095 0
+ 0.00025105 1 0.00049995 1 0.00050005 0 0.00100095 0 0.00100105 1 0.00104995 1
+ 0.00105005 0 0.00145095 0 0.00145105 1 0.00149995 1 0.00150005 0 0.00205095 0
+ 0.00205105 1 0.00209995 1 0.00210005 0 0.00215095 0 0.00215105 1 0.00279995 1
+ 0.00280005 0 0.00335095 0 0.00335105 1 0.00344995 1 0.00345005 0 0.00350095 0
+ 0.00350105 1 0.00379995 1 0.00380005 0 0.00385095 0 0.00385105 1 0.00389995 1
+ 0.00390005 0 0.00395095 0 0.00395105 1 0.00404995 1 0.00405005 0 0.00410095 0
+ 0.00410105 1 0.00419995 1 0.00420005 0 0.00425095 0 0.00425105 1 0.00434995 1
+ 0.00435005 0 0.00440095 0 0.00440105 1 0.00459995 1 0.00460005 0 0.00465095 0
+ 0.00465105 1 0.00479995 1 0.00480005 0 0.00485095 0 0.00485105 1 0.00494995 1
+ 0.00495005 0 0.00500095 0 0.00500105 1 0.00504995 1 0.00505005 0 0.00510095 0
+ 0.00510105 1 0.00519995 1 0.00520005 0 0.00525095 0 0.00525105 1 0.00539995 1
+ 0.00540005 0 0.00545095 0 0.00545105 1 0.00549995 1 0.00550005 0 0.00555095 0
+ 0.00555105 1 0.00564995 1 0.00565005 0 0.00570095 0 0.00570105 1 0.00589995 1
+ 0.00590005 0 0.00595095 0 0.00595105 1 0.00609995 1 0.00610005 0 0.00615095 0
+ 0.00615105 1 0.00619995 1 0.00620005 0 0.00625095 0 0.00625105 1 0.00639995 1
+ 0.00640005 0 0.00645095 0 0.00645105 1 0.00649995 1 0.00650005 0 0.00655095 0
+ 0.00655105 1 0.00664995 1 0.00665005 0 0.00755095 0 0.00755105 1 0.00764995 1
+ 0.00765005 0 0.00770095 0 0.00770105 1 0.00779995 1 0.00780005 0 0.00800095 0
+ 0.00800105 1 0.00809995 1 0.00810005 0 0.00815095 0 0.00815105 1 0.00824995 1
+ 0.00825005 0 0.00945095 0 0.00945105 1 0.00949995 1 0.00950005 0 0.00960095 0
+ 0.00960105 1 0.00964995 1 0.00965005 0 0.01005095 0 0.01005105 1 0.01014995 1
+ 0.01015005 0 0.01020095 0 0.01020105 1 0.01029995 1 0.01030005 0 0.01260095 0
+ 0.01260105 1 0.01269995 1 0.01270005 0 0.01315095 0 0.01315105 1 0.01329995 1
+ 0.01330005 0 0.01345095 0 0.01345105 1 0.01354995 1 0.01355005 0 0.01360095 0
+ 0.01360105 1 0.01369995 1 0.01370005 0 0.01420095 0 0.01420105 1 0.01424995 1
+ 0.01425005 0 0.01430095 0 0.01430105 1 0.01439995 1 0.01440005 0 0.01520095 0
+ 0.01520105 1 0.01524995 1 0.01525005 0 0.01535095 0 0.01535105 1 0.01539995 1
+ 0.01540005 0 0.01545095 0 0.01545105 1 0.01554995 1 0.01555005 0 0.01560095 0
+ 0.01560105 1 0.01574995 1 0.01575005 0 0.01580095 0 0.01580105 1 0.01589995 1
+ 0.01590005 0 0.01595095 0 0.01595105 1 0.01604995 1 0.01605005 0 0.01695095 0
+ 0.01695105 1 0.01699995 1 0.01700005 0 0.01710095 0 0.01710105 1 0.01714995 1
+ 0.01715005 0 0.01720095 0 0.01720105 1 0.01724995 1 0.01725005 0 0.01730095 0
+ 0.01730105 1 0.01739995 1 0.01740005 0 0.01750095 0 0.01750105 1 0.01754995 1
+ 0.01755005 0 0.01765095 0 0.01765105 1 0.01769995 1 0.01770005 0 0.01790095 0
+ 0.01790105 1 0.01794995 1 0.01795005 0 0.01805095 0 0.01805105 1 0.01809995 1
+ 0.01810005 0 0.01820095 0 0.01820105 1 0.01824995 1 0.01825005 0 0.01830095 0
+ 0.01830105 1 0.01834995 1 0.01835005 0 0.01845095 0 0.01845105 1 0.01854995 1
+ 0.01855005 0 0.01860095 0 0.01860105 1 0.01864995 1 0.01865005 0 0.01870095 0
+ 0.01870105 1 0.01879995 1 0.01880005 0 0.01890095 0 0.01890105 1 0.01894995 1
+ 0.01895005 0 0.01900095 0 0.01900105 1 0.01904995 1 0.01905005 0 0.01915095 0
+ 0.01915105 1 0.01919995 1 0.01920005 0 0.01940095 0 0.01940105 1 0.01949995 1
+ 0.01950005 0 0.01995095 0 0.01995105 1 0.02004995 1 0.02005005 0 0.02010095 0
+ 0.02010105 1 0.02014995 1 0.02015005 0 0.02025095 0 0.02025105 1 0.02029995 1
+ 0.02030005 0 0.02035095 0 0.02035105 1 0.02044995 1 0.02045005 0 0.02065095 0
+ 0.02065105 1 0.02069995 1 0.02070005 0 0.02075095 0 0.02075105 1 0.02084995 1
+ 0.02085005 0 0.02180095 0 0.02180105 1 0.02189995 1 0.02190005 0 0.02195095 0
+ 0.02195105 1 0.02204995 1 0.02205005 0 0.02210095 0 0.02210105 1 0.02219995 1
+ 0.02220005 0 0.02755095 0 0.02755105 1 0.02759995 1 0.02760005 0 0.02765095 0
+ 0.02765105 1 0.02799995 1 0.02800005 0 0.02815095 0 0.02815105 1 0.02819995 1
+ 0.02820005 0 0.02825095 0 0.02825105 1 0.02879995 1 0.02880005 0 0.02885095 0
+ 0.02885105 1 0.02889995 1 0.02890005 0 0.02920095 0 0.02920105 1 0.02924995 1
+ 0.02925005 0 0.02935095 0 0.02935105 1 0.02944995 1 0.02945005 0 0.02950095 0
+ 0.02950105 1 0.02974995 1 0.02975005 0 0.02980095 0 0.02980105 1 0.02989995 1
+ 0.02990005 0 0.02995095 0 0.02995105 1 0.03004995 1 0.03005005 0 0.03010095 0
+ 0.03010105 1 0.03029995 1 0.03030005 0 0.03050095 0 0.03050105 1 0.03079995 1
+ 0.03080005 0 0.03110095 0 0.03110105 1 0.03119995 1 0.03120005 0 0.03125095 0
+ 0.03125105 1 0.03144995 1 0.03145005 0 0.03150095 0 0.03150105 1 0.03159995 1
+ 0.03160005 0 0.03165095 0 0.03165105 1 0.03179995 1 0.03180005 0 0.03185095 0
+ 0.03185105 1 0.03204995 1 0.03205005 0 0.03210095 0 0.03210105 1 0.03229995 1
+ 0.03230005 0 0.03235095 0 0.03235105 1 0.03284995 1 0.03285005 0 0.03290095 0
+ 0.03290105 1 0.03314995 1 0.03315005 0 0.03320095 0 0.03320105 1 0.03344995 1
+ 0.03345005 0 0.03350095 0 0.03350105 1 0.03374995 1 0.03375005 0 0.03390095 0
+ 0.03390105 1 0.03414995 1 0.03415005 0 0.03465095 0 0.03465105 1 0.03474995 1
+ 0.03475005 0 0.03575095 0 0.03575105 1 0.03579995 1 0.03580005 0 0.03920095 0
+ 0.03920105 1 0.03944995 1 0.03945005 0 0.03950095 0 0.03950105 1 0.03969995 1
+ 0.03970005 0 0.04050095 0 0.04050105 1 0.04054995 1 0.04055005 0 0.04095095 0
+ 0.04095105 1 0.04099995 1 0.04100005 0 0.04140095 0 0.04140105 1 0.04144995 1
+ 0.04145005 0 0.04150095 0 0.04150105 1 0.04194995 1 0.04195005 0 0.04235095 0
+ 0.04235105 1 0.04239995 1 0.04240005 0 0.04245095 0 0.04245105 1 0.04274995 1
+ 0.04275005 0 0.04280095 0 0.04280105 1 0.04309995 1 0.04310005 0 0.04315095 0
+ 0.04315105 1 0.04324995 1 0.04325005 0 0.04330095 0 0.04330105 1 0.04354995 1
+ 0.04355005 0 0.04360095 0 0.04360105 1 0.04364995 1 0.04365005 0 0.04370095 0
+ 0.04370105 1 0.04384995 1 0.04385005 0 0.04390095 0 0.04390105 1 0.04419995 1
+ 0.04420005 0 0.04425095 0 0.04425105 1 0.04429995 1 0.04430005 0 0.04435095 0
+ 0.04435105 1 0.04444995 1 0.04445005 0 0.04450095 0 0.04450105 1 0.04474995 1
+ 0.04475005 0 0.04480095 0 0.04480105 1 0.04489995 1 0.04490005 0 0.04495095 0
+ 0.04495105 1 0.04519995 1 0.04520005 0 0.04525095 0 0.04525105 1 0.04534995 1
+ 0.04535005 0 0.04540095 0 0.04540105 1 0.04554995 1 0.04555005 0 0.04560095 0
+ 0.04560105 1 0.04564995 1 0.04565005 0 0.04570095 0 0.04570105 1 0.04594995 1
+ 0.04595005 0 0.04600095 0 0.04600105 1 0.04609995 1 0.04610005 0 0.04615095 0
+ 0.04615105 1 0.04624995 1 0.04625005 0 0.04630095 0 0.04630105 1 0.04639995 1
+ 0.04640005 0 0.04645095 0 0.04645105 1 0.04654995 1 0.04655005 0 0.04660095 0
+ 0.04660105 1 0.04669995 1 0.04670005 0 0.04680095 0 0.04680105 1 0.04684995 1
+ 0.04685005 0 0.04690095 0 0.04690105 1 0.04704995 1 0.04705005 0 0.04720095 0
+ 0.04720105 1 0.04729995 1 0.04730005 0 0.04735095 0 0.04735105 1 0.04744995 1
+ 0.04745005 0 0.0512 0
+ )
Vgc2 gc2 0 PWL(
+ 0 1 0.00064995 1 0.00065005 0 0.00070095 0 0.00070105 1 0.00074995 1
+ 0.00075005 0 0.00085095 0 0.00085105 1 0.00109995 1 0.00110005 0 0.00120095 0
+ 0.00120105 1 0.00124995 1 0.00125005 0 0.00130095 0 0.00130105 1 0.00154995 1
+ 0.00155005 0 0.00165095 0 0.00165105 1 0.00169995 1 0.00170005 0 0.00180095 0
+ 0.00180105 1 0.00184995 1 0.00185005 0 0.00190095 0 0.00190105 1 0.00284995 1
+ 0.00285005 0 0.00290095 0 0.00290105 1 0.00299995 1 0.00300005 0 0.00310095 0
+ 0.00310105 1 0.00314995 1 0.00315005 0 0.00325095 0 0.00325105 1 0.00669995 1
+ 0.00670005 0 0.00690095 0 0.00690105 1 0.00699995 1 0.00700005 0 0.00735095 0
+ 0.00735105 1 0.00744995 1 0.00745005 0 0.00750095 0 0.00750105 1 0.00789995 1
+ 0.00790005 0 0.00795095 0 0.00795105 1 0.00844995 1 0.00845005 0 0.00915095 0
+ 0.00915105 1 0.00919995 1 0.00920005 0 0.00930095 0 0.00930105 1 0.00984995 1
+ 0.00985005 0 0.00995095 0 0.00995105 1 0.01039995 1 0.01040005 0 0.01050095 0
+ 0.01050105 1 0.01054995 1 0.01055005 0 0.01065095 0 0.01065105 1 0.01069995 1
+ 0.01070005 0 0.01080095 0 0.01080105 1 0.01084995 1 0.01085005 0 0.01105095 0
+ 0.01105105 1 0.01109995 1 0.01110005 0 0.01140095 0 0.01140105 1 0.01144995 1
+ 0.01145005 0 0.01165095 0 0.01165105 1 0.01169995 1 0.01170005 0 0.01180095 0
+ 0.01180105 1 0.01194995 1 0.01195005 0 0.01205095 0 0.01205105 1 0.01209995 1
+ 0.01210005 0 0.01230095 0 0.01230105 1 0.01234995 1 0.01235005 0 0.01250095 0
+ 0.01250105 1 0.01279995 1 0.01280005 0 0.01305095 0 0.01305105 1 0.01389995 1
+ 0.01390005 0 0.01405095 0 0.01405105 1 0.01409995 1 0.01410005 0 0.01415095 0
+ 0.01415105 1 0.01474995 1 0.01475005 0 0.01500095 0 0.01500105 1 0.01509995 1
+ 0.01510005 0 0.01515095 0 0.01515105 1 0.01614995 1 0.01615005 0 0.01625095 0
+ 0.01625105 1 0.01629995 1 0.01630005 0 0.01640095 0 0.01640105 1 0.01644995 1
+ 0.01645005 0 0.01690095 0 0.01690105 1 0.01959995 1 0.01960005 0 0.01990095 0
+ 0.01990105 1 0.02094995 1 0.02095005 0 0.02150095 0 0.02150105 1 0.02164995 1
+ 0.02165005 0 0.02175095 0 0.02175105 1 0.02259995 1 0.02260005 0 0.02265095 0
+ 0.02265105 1 0.02274995 1 0.02275005 0 0.02315095 0 0.02315105 1 0.02319995 1
+ 0.02320005 0 0.02330095 0 0.02330105 1 0.02334995 1 0.02335005 0 0.02340095 0
+ 0.02340105 1 0.02344995 1 0.02345005 0 0.02350095 0 0.02350105 1 0.02354995 1
+ 0.02355005 0 0.02385095 0 0.02385105 1 0.02389995 1 0.02390005 0 0.02400095 0
+ 0.02400105 1 0.02404995 1 0.02405005 0 0.02410095 0 0.02410105 1 0.02414995 1
+ 0.02415005 0 0.02425095 0 0.02425105 1 0.02429995 1 0.02430005 0 0.02440095 0
+ 0.02440105 1 0.02444995 1 0.02445005 0 0.02465095 0 0.02465105 1 0.02469995 1
+ 0.02470005 0 0.02500095 0 0.02500105 1 0.02504995 1 0.02505005 0 0.02510095 0
+ 0.02510105 1 0.02514995 1 0.02515005 0 0.02525095 0 0.02525105 1 0.02529995 1
+ 0.02530005 0 0.02540095 0 0.02540105 1 0.02544995 1 0.02545005 0 0.02550095 0
+ 0.02550105 1 0.02554995 1 0.02555005 0 0.02575095 0 0.02575105 1 0.02579995 1
+ 0.02580005 0 0.02595095 0 0.02595105 1 0.02599995 1 0.02600005 0 0.02605095 0
+ 0.02605105 1 0.02609995 1 0.02610005 0 0.02620095 0 0.02620105 1 0.02624995 1
+ 0.02625005 0 0.02635095 0 0.02635105 1 0.02639995 1 0.02640005 0 0.02650095 0
+ 0.02650105 1 0.02654995 1 0.02655005 0 0.02660095 0 0.02660105 1 0.02664995 1
+ 0.02665005 0 0.02685095 0 0.02685105 1 0.02694995 1 0.02695005 0 0.02710095 0
+ 0.02710105 1 0.02714995 1 0.02715005 0 0.02720095 0 0.02720105 1 0.02724995 1
+ 0.02725005 0 0.02730095 0 0.02730105 1 0.02734995 1 0.02735005 0 0.02750095 0
+ 0.02750105 1 0.03034995 1 0.03035005 0 0.03040095 0 0.03040105 1 0.03089995 1
+ 0.03090005 0 0.03100095 0 0.03100105 1 0.03419995 1 0.03420005 0 0.03425095 0
+ 0.03425105 1 0.03429995 1 0.03430005 0 0.03440095 0 0.03440105 1 0.03444995 1
+ 0.03445005 0 0.03455095 0 0.03455105 1 0.03479995 1 0.03480005 0 0.03485095 0
+ 0.03485105 1 0.03489995 1 0.03490005 0 0.03500095 0 0.03500105 1 0.03504995 1
+ 0.03505005 0 0.03520095 0 0.03520105 1 0.03524995 1 0.03525005 0 0.03535095 0
+ 0.03535105 1 0.03539995 1 0.03540005 0 0.03550095 0 0.03550105 1 0.03559995 1
+ 0.03560005 0 0.03565095 0 0.03565105 1 0.03589995 1 0.03590005 0 0.03595095 0
+ 0.03595105 1 0.03604995 1 0.03605005 0 0.03610095 0 0.03610105 1 0.03619995 1
+ 0.03620005 0 0.03625095 0 0.03625105 1 0.03634995 1 0.03635005 0 0.03645095 0
+ 0.03645105 1 0.03649995 1 0.03650005 0 0.03660095 0 0.03660105 1 0.03669995 1
+ 0.03670005 0 0.03675095 0 0.03675105 1 0.03689995 1 0.03690005 0 0.03700095 0
+ 0.03700105 1 0.03709995 1 0.03710005 0 0.03715095 0 0.03715105 1 0.03724995 1
+ 0.03725005 0 0.03735095 0 0.03735105 1 0.03739995 1 0.03740005 0 0.03750095 0
+ 0.03750105 1 0.03764995 1 0.03765005 0 0.03775095 0 0.03775105 1 0.03784995 1
+ 0.03785005 0 0.03795095 0 0.03795105 1 0.03799995 1 0.03800005 0 0.03805095 0
+ 0.03805105 1 0.03809995 1 0.03810005 0 0.03820095 0 0.03820105 1 0.03824995 1
+ 0.03825005 0 0.03835095 0 0.03835105 1 0.03844995 1 0.03845005 0 0.03850095 0
+ 0.03850105 1 0.03854995 1 0.03855005 0 0.03865095 0 0.03865105 1 0.03869995 1
+ 0.03870005 0 0.03880095 0 0.03880105 1 0.03884995 1 0.03885005 0 0.03890095 0
+ 0.03890105 1 0.03899995 1 0.03900005 0 0.03910095 0 0.03910105 1 0.03974995 1
+ 0.03975005 0 0.03980095 0 0.03980105 1 0.03984995 1 0.03985005 0 0.03995095 0
+ 0.03995105 1 0.04014995 1 0.04015005 0 0.04025095 0 0.04025105 1 0.04029995 1
+ 0.04030005 0 0.04040095 0 0.04040105 1 0.04059995 1 0.04060005 0 0.04070095 0
+ 0.04070105 1 0.04074995 1 0.04075005 0 0.04080095 0 0.04080105 1 0.04104995 1
+ 0.04105005 0 0.04115095 0 0.04115105 1 0.04119995 1 0.04120005 0 0.04125095 0
+ 0.04125105 1 0.04199995 1 0.04200005 0 0.04205095 0 0.04205105 1 0.04709995 1
+ 0.04710005 0 0.04715095 0 0.04715105 1 0.04754995 1 0.04755005 0 0.04790095 0
+ 0.04790105 1 0.04799995 1 0.04800005 0 0.04810095 0 0.04810105 1 0.04814995 1
+ 0.04815005 0 0.04855095 0 0.04855105 1 0.04859995 1 0.04860005 0 0.04870095 0
+ 0.04870105 1 0.04894995 1 0.04895005 0 0.04905095 0 0.04905105 1 0.04909995 1
+ 0.04910005 0 0.04940095 0 0.04940105 1 0.04944995 1 0.04945005 0 0.04975095 0
+ 0.04975105 1 0.04979995 1 0.04980005 0 0.05010095 0 0.05010105 1 0.05014995 1
+ 0.05015005 0 0.05025095 0 0.05025105 1 0.05029995 1 0.05030005 0 0.05070095 0
+ 0.05070105 1 0.05074995 1 0.05075005 0 0.05090095 0 0.05090105 1 0.05094995 1
+ 0.05095005 0 0.05105095 0 0.05105105 1 0.05109995 1 0.05110005 0 0.0512 0
+ )
Vgc3 gc3 0 PWL(
+ 0 1 5e-08 0 0.00020095 0 0.00020105 1 0.00024995 1 0.00025005 0
+ 0.00050095 0 0.00050105 1 0.00099995 1 0.00100005 0 0.00105095 0 0.00105105 1
+ 0.00144995 1 0.00145005 0 0.00150095 0 0.00150105 1 0.00204995 1 0.00205005 0
+ 0.00210095 0 0.00210105 1 0.00214995 1 0.00215005 0 0.00280095 0 0.00280105 1
+ 0.00334995 1 0.00335005 0 0.00345095 0 0.00345105 1 0.00349995 1 0.00350005 0
+ 0.00380095 0 0.00380105 1 0.00384995 1 0.00385005 0 0.00390095 0 0.00390105 1
+ 0.00394995 1 0.00395005 0 0.00405095 0 0.00405105 1 0.00409995 1 0.00410005 0
+ 0.00420095 0 0.00420105 1 0.00424995 1 0.00425005 0 0.00435095 0 0.00435105 1
+ 0.00439995 1 0.00440005 0 0.00460095 0 0.00460105 1 0.00464995 1 0.00465005 0
+ 0.00480095 0 0.00480105 1 0.00484995 1 0.00485005 0 0.00495095 0 0.00495105 1
+ 0.00499995 1 0.00500005 0 0.00505095 0 0.00505105 1 0.00509995 1 0.00510005 0
+ 0.00520095 0 0.00520105 1 0.00524995 1 0.00525005 0 0.00540095 0 0.00540105 1
+ 0.00544995 1 0.00545005 0 0.00550095 0 0.00550105 1 0.00554995 1 0.00555005 0
+ 0.00565095 0 0.00565105 1 0.00569995 1 0.00570005 0 0.00590095 0 0.00590105 1
+ 0.00594995 1 0.00595005 0 0.00610095 0 0.00610105 1 0.00614995 1 0.00615005 0
+ 0.00620095 0 0.00620105 1 0.00624995 1 0.00625005 0 0.00640095 0 0.00640105 1
+ 0.00644995 1 0.00645005 0 0.00650095 0 0.00650105 1 0.00654995 1 0.00655005 0
+ 0.00665095 0 0.00665105 1 0.00754995 1 0.00755005 0 0.00765095 0 0.00765105 1
+ 0.00769995 1 0.00770005 0 0.00780095 0 0.00780105 1 0.00799995 1 0.00800005 0
+ 0.00810095 0 0.00810105 1 0.00814995 1 0.00815005 0 0.00825095 0 0.00825105 1
+ 0.00944995 1 0.00945005 0 0.00950095 0 0.00950105 1 0.00959995 1 0.00960005 0
+ 0.00965095 0 0.00965105 1 0.01004995 1 0.01005005 0 0.01015095 0 0.01015105 1
+ 0.01019995 1 0.01020005 0 0.01030095 0 0.01030105 1 0.01259995 1 0.01260005 0
+ 0.01270095 0 0.01270105 1 0.01314995 1 0.01315005 0 0.01330095 0 0.01330105 1
+ 0.01344995 1 0.01345005 0 0.01355095 0 0.01355105 1 0.01359995 1 0.01360005 0
+ 0.01370095 0 0.01370105 1 0.01419995 1 0.01420005 0 0.01425095 0 0.01425105 1
+ 0.01429995 1 0.01430005 0 0.01440095 0 0.01440105 1 0.01519995 1 0.01520005 0
+ 0.01525095 0 0.01525105 1 0.01534995 1 0.01535005 0 0.01540095 0 0.01540105 1
+ 0.01544995 1 0.01545005 0 0.01555095 0 0.01555105 1 0.01559995 1 0.01560005 0
+ 0.01575095 0 0.01575105 1 0.01579995 1 0.01580005 0 0.01590095 0 0.01590105 1
+ 0.01594995 1 0.01595005 0 0.01605095 0 0.01605105 1 0.01694995 1 0.01695005 0
+ 0.01700095 0 0.01700105 1 0.01709995 1 0.01710005 0 0.01715095 0 0.01715105 1
+ 0.01719995 1 0.01720005 0 0.01725095 0 0.01725105 1 0.01729995 1 0.01730005 0
+ 0.01740095 0 0.01740105 1 0.01749995 1 0.01750005 0 0.01755095 0 0.01755105 1
+ 0.01764995 1 0.01765005 0 0.01770095 0 0.01770105 1 0.01789995 1 0.01790005 0
+ 0.01795095 0 0.01795105 1 0.01804995 1 0.01805005 0 0.01810095 0 0.01810105 1
+ 0.01819995 1 0.01820005 0 0.01825095 0 0.01825105 1 0.01829995 1 0.01830005 0
+ 0.01835095 0 0.01835105 1 0.01844995 1 0.01845005 0 0.01855095 0 0.01855105 1
+ 0.01859995 1 0.01860005 0 0.01865095 0 0.01865105 1 0.01869995 1 0.01870005 0
+ 0.01880095 0 0.01880105 1 0.01889995 1 0.01890005 0 0.01895095 0 0.01895105 1
+ 0.01899995 1 0.01900005 0 0.01905095 0 0.01905105 1 0.01914995 1 0.01915005 0
+ 0.01920095 0 0.01920105 1 0.01939995 1 0.01940005 0 0.01950095 0 0.01950105 1
+ 0.01994995 1 0.01995005 0 0.02005095 0 0.02005105 1 0.02009995 1 0.02010005 0
+ 0.02015095 0 0.02015105 1 0.02024995 1 0.02025005 0 0.02030095 0 0.02030105 1
+ 0.02034995 1 0.02035005 0 0.02045095 0 0.02045105 1 0.02064995 1 0.02065005 0
+ 0.02070095 0 0.02070105 1 0.02074995 1 0.02075005 0 0.02085095 0 0.02085105 1
+ 0.02179995 1 0.02180005 0 0.02190095 0 0.02190105 1 0.02194995 1 0.02195005 0
+ 0.02205095 0 0.02205105 1 0.02209995 1 0.02210005 0 0.02220095 0 0.02220105 1
+ 0.02754995 1 0.02755005 0 0.02760095 0 0.02760105 1 0.02764995 1 0.02765005 0
+ 0.02800095 0 0.02800105 1 0.02814995 1 0.02815005 0 0.02820095 0 0.02820105 1
+ 0.02824995 1 0.02825005 0 0.02880095 0 0.02880105 1 0.02884995 1 0.02885005 0
+ 0.02890095 0 0.02890105 1 0.02919995 1 0.02920005 0 0.02925095 0 0.02925105 1
+ 0.02934995 1 0.02935005 0 0.02945095 0 0.02945105 1 0.02949995 1 0.02950005 0
+ 0.02975095 0 0.02975105 1 0.02979995 1 0.02980005 0 0.02990095 0 0.02990105 1
+ 0.02994995 1 0.02995005 0 0.03005095 0 0.03005105 1 0.03009995 1 0.03010005 0
+ 0.03030095 0 0.03030105 1 0.03049995 1 0.03050005 0 0.03080095 0 0.03080105 1
+ 0.03109995 1 0.03110005 0 0.03120095 0 0.03120105 1 0.03124995 1 0.03125005 0
+ 0.03145095 0 0.03145105 1 0.03149995 1 0.03150005 0 0.03160095 0 0.03160105 1
+ 0.03164995 1 0.03165005 0 0.03180095 0 0.03180105 1 0.03184995 1 0.03185005 0
+ 0.03205095 0 0.03205105 1 0.03209995 1 0.03210005 0 0.03230095 0 0.03230105 1
+ 0.03234995 1 0.03235005 0 0.03285095 0 0.03285105 1 0.03289995 1 0.03290005 0
+ 0.03315095 0 0.03315105 1 0.03319995 1 0.03320005 0 0.03345095 0 0.03345105 1
+ 0.03349995 1 0.03350005 0 0.03375095 0 0.03375105 1 0.03389995 1 0.03390005 0
+ 0.03415095 0 0.03415105 1 0.03464995 1 0.03465005 0 0.03475095 0 0.03475105 1
+ 0.03574995 1 0.03575005 0 0.03580095 0 0.03580105 1 0.03919995 1 0.03920005 0
+ 0.03945095 0 0.03945105 1 0.03949995 1 0.03950005 0 0.03970095 0 0.03970105 1
+ 0.04049995 1 0.04050005 0 0.04055095 0 0.04055105 1 0.04094995 1 0.04095005 0
+ 0.04100095 0 0.04100105 1 0.04139995 1 0.04140005 0 0.04145095 0 0.04145105 1
+ 0.04149995 1 0.04150005 0 0.04195095 0 0.04195105 1 0.04234995 1 0.04235005 0
+ 0.04240095 0 0.04240105 1 0.04244995 1 0.04245005 0 0.04275095 0 0.04275105 1
+ 0.04279995 1 0.04280005 0 0.04310095 0 0.04310105 1 0.04314995 1 0.04315005 0
+ 0.04325095 0 0.04325105 1 0.04329995 1 0.04330005 0 0.04355095 0 0.04355105 1
+ 0.04359995 1 0.04360005 0 0.04365095 0 0.04365105 1 0.04369995 1 0.04370005 0
+ 0.04385095 0 0.04385105 1 0.04389995 1 0.04390005 0 0.04420095 0 0.04420105 1
+ 0.04424995 1 0.04425005 0 0.04430095 0 0.04430105 1 0.04434995 1 0.04435005 0
+ 0.04445095 0 0.04445105 1 0.04449995 1 0.04450005 0 0.04475095 0 0.04475105 1
+ 0.04479995 1 0.04480005 0 0.04490095 0 0.04490105 1 0.04494995 1 0.04495005 0
+ 0.04520095 0 0.04520105 1 0.04524995 1 0.04525005 0 0.04535095 0 0.04535105 1
+ 0.04539995 1 0.04540005 0 0.04555095 0 0.04555105 1 0.04559995 1 0.04560005 0
+ 0.04565095 0 0.04565105 1 0.04569995 1 0.04570005 0 0.04595095 0 0.04595105 1
+ 0.04599995 1 0.04600005 0 0.04610095 0 0.04610105 1 0.04614995 1 0.04615005 0
+ 0.04625095 0 0.04625105 1 0.04629995 1 0.04630005 0 0.04640095 0 0.04640105 1
+ 0.04644995 1 0.04645005 0 0.04655095 0 0.04655105 1 0.04659995 1 0.04660005 0
+ 0.04670095 0 0.04670105 1 0.04679995 1 0.04680005 0 0.04685095 0 0.04685105 1
+ 0.04689995 1 0.04690005 0 0.04705095 0 0.04705105 1 0.04719995 1 0.04720005 0
+ 0.04730095 0 0.04730105 1 0.04734995 1 0.04735005 0 0.04745095 0 0.04745105 1
+ 0.0512 1
+ )
Vgc4 gc4 0 PWL(
+ 0 0 0.00065095 0 0.00065105 1 0.00069995 1 0.00070005 0 0.00075095 0
+ 0.00075105 1 0.00084995 1 0.00085005 0 0.00110095 0 0.00110105 1 0.00119995 1
+ 0.00120005 0 0.00125095 0 0.00125105 1 0.00129995 1 0.00130005 0 0.00155095 0
+ 0.00155105 1 0.00164995 1 0.00165005 0 0.00170095 0 0.00170105 1 0.00179995 1
+ 0.00180005 0 0.00185095 0 0.00185105 1 0.00189995 1 0.00190005 0 0.00285095 0
+ 0.00285105 1 0.00289995 1 0.00290005 0 0.00300095 0 0.00300105 1 0.00309995 1
+ 0.00310005 0 0.00315095 0 0.00315105 1 0.00324995 1 0.00325005 0 0.00670095 0
+ 0.00670105 1 0.00689995 1 0.00690005 0 0.00700095 0 0.00700105 1 0.00734995 1
+ 0.00735005 0 0.00745095 0 0.00745105 1 0.00749995 1 0.00750005 0 0.00790095 0
+ 0.00790105 1 0.00794995 1 0.00795005 0 0.00845095 0 0.00845105 1 0.00914995 1
+ 0.00915005 0 0.00920095 0 0.00920105 1 0.00929995 1 0.00930005 0 0.00985095 0
+ 0.00985105 1 0.00994995 1 0.00995005 0 0.01040095 0 0.01040105 1 0.01049995 1
+ 0.01050005 0 0.01055095 0 0.01055105 1 0.01064995 1 0.01065005 0 0.01070095 0
+ 0.01070105 1 0.01079995 1 0.01080005 0 0.01085095 0 0.01085105 1 0.01104995 1
+ 0.01105005 0 0.01110095 0 0.01110105 1 0.01139995 1 0.01140005 0 0.01145095 0
+ 0.01145105 1 0.01164995 1 0.01165005 0 0.01170095 0 0.01170105 1 0.01179995 1
+ 0.01180005 0 0.01195095 0 0.01195105 1 0.01204995 1 0.01205005 0 0.01210095 0
+ 0.01210105 1 0.01229995 1 0.01230005 0 0.01235095 0 0.01235105 1 0.01249995 1
+ 0.01250005 0 0.01280095 0 0.01280105 1 0.01304995 1 0.01305005 0 0.01390095 0
+ 0.01390105 1 0.01404995 1 0.01405005 0 0.01410095 0 0.01410105 1 0.01414995 1
+ 0.01415005 0 0.01475095 0 0.01475105 1 0.01499995 1 0.01500005 0 0.01510095 0
+ 0.01510105 1 0.01514995 1 0.01515005 0 0.01615095 0 0.01615105 1 0.01624995 1
+ 0.01625005 0 0.01630095 0 0.01630105 1 0.01639995 1 0.01640005 0 0.01645095 0
+ 0.01645105 1 0.01689995 1 0.01690005 0 0.01960095 0 0.01960105 1 0.01989995 1
+ 0.01990005 0 0.02095095 0 0.02095105 1 0.02149995 1 0.02150005 0 0.02165095 0
+ 0.02165105 1 0.02174995 1 0.02175005 0 0.02260095 0 0.02260105 1 0.02264995 1
+ 0.02265005 0 0.02275095 0 0.02275105 1 0.02314995 1 0.02315005 0 0.02320095 0
+ 0.02320105 1 0.02329995 1 0.02330005 0 0.02335095 0 0.02335105 1 0.02339995 1
+ 0.02340005 0 0.02345095 0 0.02345105 1 0.02349995 1 0.02350005 0 0.02355095 0
+ 0.02355105 1 0.02384995 1 0.02385005 0 0.02390095 0 0.02390105 1 0.02399995 1
+ 0.02400005 0 0.02405095 0 0.02405105 1 0.02409995 1 0.02410005 0 0.02415095 0
+ 0.02415105 1 0.02424995 1 0.02425005 0 0.02430095 0 0.02430105 1 0.02439995 1
+ 0.02440005 0 0.02445095 0 0.02445105 1 0.02464995 1 0.02465005 0 0.02470095 0
+ 0.02470105 1 0.02499995 1 0.02500005 0 0.02505095 0 0.02505105 1 0.02509995 1
+ 0.02510005 0 0.02515095 0 0.02515105 1 0.02524995 1 0.02525005 0 0.02530095 0
+ 0.02530105 1 0.02539995 1 0.02540005 0 0.02545095 0 0.02545105 1 0.02549995 1
+ 0.02550005 0 0.02555095 0 0.02555105 1 0.02574995 1 0.02575005 0 0.02580095 0
+ 0.02580105 1 0.02594995 1 0.02595005 0 0.02600095 0 0.02600105 1 0.02604995 1
+ 0.02605005 0 0.02610095 0 0.02610105 1 0.02619995 1 0.02620005 0 0.02625095 0
+ 0.02625105 1 0.02634995 1 0.02635005 0 0.02640095 0 0.02640105 1 0.02649995 1
+ 0.02650005 0 0.02655095 0 0.02655105 1 0.02659995 1 0.02660005 0 0.02665095 0
+ 0.02665105 1 0.02684995 1 0.02685005 0 0.02695095 0 0.02695105 1 0.02709995 1
+ 0.02710005 0 0.02715095 0 0.02715105 1 0.02719995 1 0.02720005 0 0.02725095 0
+ 0.02725105 1 0.02729995 1 0.02730005 0 0.02735095 0 0.02735105 1 0.02749995 1
+ 0.02750005 0 0.03035095 0 0.03035105 1 0.03039995 1 0.03040005 0 0.03090095 0
+ 0.03090105 1 0.03099995 1 0.03100005 0 0.03420095 0 0.03420105 1 0.03424995 1
+ 0.03425005 0 0.03430095 0 0.03430105 1 0.03439995 1 0.03440005 0 0.03445095 0
+ 0.03445105 1 0.03454995 1 0.03455005 0 0.03480095 0 0.03480105 1 0.03484995 1
+ 0.03485005 0 0.03490095 0 0.03490105 1 0.03499995 1 0.03500005 0 0.03505095 0
+ 0.03505105 1 0.03519995 1 0.03520005 0 0.03525095 0 0.03525105 1 0.03534995 1
+ 0.03535005 0 0.03540095 0 0.03540105 1 0.03549995 1 0.03550005 0 0.03560095 0
+ 0.03560105 1 0.03564995 1 0.03565005 0 0.03590095 0 0.03590105 1 0.03594995 1
+ 0.03595005 0 0.03605095 0 0.03605105 1 0.03609995 1 0.03610005 0 0.03620095 0
+ 0.03620105 1 0.03624995 1 0.03625005 0 0.03635095 0 0.03635105 1 0.03644995 1
+ 0.03645005 0 0.03650095 0 0.03650105 1 0.03659995 1 0.03660005 0 0.03670095 0
+ 0.03670105 1 0.03674995 1 0.03675005 0 0.03690095 0 0.03690105 1 0.03699995 1
+ 0.03700005 0 0.03710095 0 0.03710105 1 0.03714995 1 0.03715005 0 0.03725095 0
+ 0.03725105 1 0.03734995 1 0.03735005 0 0.03740095 0 0.03740105 1 0.03749995 1
+ 0.03750005 0 0.03765095 0 0.03765105 1 0.03774995 1 0.03775005 0 0.03785095 0
+ 0.03785105 1 0.03794995 1 0.03795005 0 0.03800095 0 0.03800105 1 0.03804995 1
+ 0.03805005 0 0.03810095 0 0.03810105 1 0.03819995 1 0.03820005 0 0.03825095 0
+ 0.03825105 1 0.03834995 1 0.03835005 0 0.03845095 0 0.03845105 1 0.03849995 1
+ 0.03850005 0 0.03855095 0 0.03855105 1 0.03864995 1 0.03865005 0 0.03870095 0
+ 0.03870105 1 0.03879995 1 0.03880005 0 0.03885095 0 0.03885105 1 0.03889995 1
+ 0.03890005 0 0.03900095 0 0.03900105 1 0.03909995 1 0.03910005 0 0.03975095 0
+ 0.03975105 1 0.03979995 1 0.03980005 0 0.03985095 0 0.03985105 1 0.03994995 1
+ 0.03995005 0 0.04015095 0 0.04015105 1 0.04024995 1 0.04025005 0 0.04030095 0
+ 0.04030105 1 0.04039995 1 0.04040005 0 0.04060095 0 0.04060105 1 0.04069995 1
+ 0.04070005 0 0.04075095 0 0.04075105 1 0.04079995 1 0.04080005 0 0.04105095 0
+ 0.04105105 1 0.04114995 1 0.04115005 0 0.04120095 0 0.04120105 1 0.04124995 1
+ 0.04125005 0 0.04200095 0 0.04200105 1 0.04204995 1 0.04205005 0 0.04710095 0
+ 0.04710105 1 0.04714995 1 0.04715005 0 0.04755095 0 0.04755105 1 0.04789995 1
+ 0.04790005 0 0.04800095 0 0.04800105 1 0.04809995 1 0.04810005 0 0.04815095 0
+ 0.04815105 1 0.04854995 1 0.04855005 0 0.04860095 0 0.04860105 1 0.04869995 1
+ 0.04870005 0 0.04895095 0 0.04895105 1 0.04904995 1 0.04905005 0 0.04910095 0
+ 0.04910105 1 0.04939995 1 0.04940005 0 0.04945095 0 0.04945105 1 0.04974995 1
+ 0.04975005 0 0.04980095 0 0.04980105 1 0.05009995 1 0.05010005 0 0.05015095 0
+ 0.05015105 1 0.05024995 1 0.05025005 0 0.05030095 0 0.05030105 1 0.05069995 1
+ 0.05070005 0 0.05075095 0 0.05075105 1 0.05089995 1 0.05090005 0 0.05095095 0
+ 0.05095105 1 0.05104995 1 0.05105005 0 0.05110095 0 0.05110105 1 0.0512 1
+ )
Bswc1 pos yc1 I=V(pos,yc1)*1e-6*exp(18.42068074395*V(gc1))
Rwirec1 yc1 xc1 0.01
Dsc1 xc1 pc transistorD
Dac1 pc pos antiparallelD
Bswc2 0 yc2 I=V(0,yc2)*1e-6*exp(18.42068074395*V(gc2))
Rwirec2 yc2 xc2 0.01
Dsc2 xc2 mc transistorD
Dac2 mc 0 antiparallelD
Bswc3 pc yc3 I=V(pc,yc3)*1e-6*exp(18.42068074395*V(gc3))
Rwirec3 yc3 xc3 0.01
Dsc3 xc3 mc transistorD
Dac3 mc pc antiparallelD
Bswc4 pc yc4 I=V(pc,yc4)*1e-6*exp(18.42068074395*V(gc4))
Rwirec4 yc4 xc4 0.01
Dsc4 xc4 neg transistorD
Dac4 neg pc antiparallelD
Lc pc rc 0.002 IC=0
Rc rc ec 0.25
Bemfc ec neutral V=20*sin(2*pi*25*time+(-240)*pi/180)*min(time/1e-6,1)
.control
set klu
set noaskquit
set numdgt=15
set wr_singlescale
set wr_vecnames
tran 5e-05 0.0512 0 1.25e-07
linearize i(La) i(Lb) i(Lc)
wrdata audit_tolB125_current.txt i(La) i(Lb) i(Lc)
quit
.endc
.end
